ADE simulation setup
Run mode: Single Run, Sweeps and Corners
Tests:
  active_probe (off): HW09_Mixers/active_tb/schematic, simulator spectre
  active_single_tone: HW09_Mixers/active_tb/schematic, simulator spectre
    Variables: pinDbm = -55; fRF = 5800000000.0; fRF2 = 5800000000.0; tone2Scale = 0; rfScale = 1
  active_single_window_check: HW09_Mixers/active_tb/schematic, simulator spectre
    Variables: pinDbm = -55; fRF = 5800000000.0; fRF2 = 5800000000.0; tone2Scale = 0; rfScale = 1
  active_compression_00: HW09_Mixers/active_tb/schematic, simulator spectre
    Variables: pinDbm = -60; fRF = 5800000000.0; fRF2 = 5800000000.0; tone2Scale = 0; rfScale = 1
  active_compression_01: HW09_Mixers/active_tb/schematic, simulator spectre
    Variables: pinDbm = -50; fRF = 5800000000.0; fRF2 = 5800000000.0; tone2Scale = 0; rfScale = 1
  active_compression_02: HW09_Mixers/active_tb/schematic, simulator spectre
    Variables: pinDbm = -40; fRF = 5800000000.0; fRF2 = 5800000000.0; tone2Scale = 0; rfScale = 1
  active_compression_03: HW09_Mixers/active_tb/schematic, simulator spectre
    Variables: pinDbm = -35; fRF = 5800000000.0; fRF2 = 5800000000.0; tone2Scale = 0; rfScale = 1
  active_compression_04: HW09_Mixers/active_tb/schematic, simulator spectre
    Variables: pinDbm = -30; fRF = 5800000000.0; fRF2 = 5800000000.0; tone2Scale = 0; rfScale = 1
  active_compression_05: HW09_Mixers/active_tb/schematic, simulator spectre
    Variables: pinDbm = -25; fRF = 5800000000.0; fRF2 = 5800000000.0; tone2Scale = 0; rfScale = 1
  active_compression_06: HW09_Mixers/active_tb/schematic, simulator spectre
    Variables: pinDbm = -20; fRF = 5800000000.0; fRF2 = 5800000000.0; tone2Scale = 0; rfScale = 1
  active_compression_07: HW09_Mixers/active_tb/schematic, simulator spectre
    Variables: pinDbm = -17.5; fRF = 5800000000.0; fRF2 = 5800000000.0; tone2Scale = 0; rfScale = 1
  active_compression_08: HW09_Mixers/active_tb/schematic, simulator spectre
    Variables: pinDbm = -16.25; fRF = 5800000000.0; fRF2 = 5800000000.0; tone2Scale = 0; rfScale = 1
  active_compression_09: HW09_Mixers/active_tb/schematic, simulator spectre
    Variables: pinDbm = -15.625; fRF = 5800000000.0; fRF2 = 5800000000.0; tone2Scale = 0; rfScale = 1
  active_compression_10: HW09_Mixers/active_tb/schematic, simulator spectre
    Variables: pinDbm = -15.46875; fRF = 5800000000.0; fRF2 = 5800000000.0; tone2Scale = 0; rfScale = 1
  active_compression_11: HW09_Mixers/active_tb/schematic, simulator spectre
    Variables: pinDbm = -15.15625; fRF = 5800000000.0; fRF2 = 5800000000.0; tone2Scale = 0; rfScale = 1
  active_compression_12: HW09_Mixers/active_tb/schematic, simulator spectre
    Variables: pinDbm = -15; fRF = 5800000000.0; fRF2 = 5800000000.0; tone2Scale = 0; rfScale = 1
  active_compression_13: HW09_Mixers/active_tb/schematic, simulator spectre
    Variables: pinDbm = -10; fRF = 5800000000.0; fRF2 = 5800000000.0; tone2Scale = 0; rfScale = 1
  active_two_tone_00: HW09_Mixers/active_tb/schematic, simulator spectre
    Variables: pinDbm = -50; fRF = 5790000000.0; fRF2 = 5810000000.0; tone2Scale = 1; rfScale = 1
  active_two_tone_01: HW09_Mixers/active_tb/schematic, simulator spectre
    Variables: pinDbm = -45; fRF = 5790000000.0; fRF2 = 5810000000.0; tone2Scale = 1; rfScale = 1
  active_two_tone_02: HW09_Mixers/active_tb/schematic, simulator spectre
    Variables: pinDbm = -40; fRF = 5790000000.0; fRF2 = 5810000000.0; tone2Scale = 1; rfScale = 1
  active_two_tone_03: HW09_Mixers/active_tb/schematic, simulator spectre
    Variables: pinDbm = -35; fRF = 5790000000.0; fRF2 = 5810000000.0; tone2Scale = 1; rfScale = 1
  active_two_tone_04: HW09_Mixers/active_tb/schematic, simulator spectre
    Variables: pinDbm = -30; fRF = 5790000000.0; fRF2 = 5810000000.0; tone2Scale = 1; rfScale = 1
  active_two_tone_05: HW09_Mixers/active_tb/schematic, simulator spectre
    Variables: pinDbm = -25; fRF = 5790000000.0; fRF2 = 5810000000.0; tone2Scale = 1; rfScale = 1
  active_two_tone_06: HW09_Mixers/active_tb/schematic, simulator spectre
    Variables: pinDbm = -20; fRF = 5790000000.0; fRF2 = 5810000000.0; tone2Scale = 1; rfScale = 1
  active_two_tone_tight: HW09_Mixers/active_tb/schematic, simulator spectre
    Variables: pinDbm = -35; fRF = 5790000000.0; fRF2 = 5810000000.0; tone2Scale = 1; rfScale = 1
  passive_single_tone: HW09_Mixers/passive_tb/schematic, simulator spectre
    Variables: pinDbm = -55; fRF = 5800000000.0; fRF2 = 5800000000.0; tone2Scale = 0; rfScale = 1
  passive_single_window_check: HW09_Mixers/passive_tb/schematic, simulator spectre
    Variables: pinDbm = -55; fRF = 5800000000.0; fRF2 = 5800000000.0; tone2Scale = 0; rfScale = 1
  passive_compression_00: HW09_Mixers/passive_tb/schematic, simulator spectre
    Variables: pinDbm = -60; fRF = 5800000000.0; fRF2 = 5800000000.0; tone2Scale = 0; rfScale = 1
  passive_compression_01: HW09_Mixers/passive_tb/schematic, simulator spectre
    Variables: pinDbm = -50; fRF = 5800000000.0; fRF2 = 5800000000.0; tone2Scale = 0; rfScale = 1
  passive_compression_02: HW09_Mixers/passive_tb/schematic, simulator spectre
    Variables: pinDbm = -40; fRF = 5800000000.0; fRF2 = 5800000000.0; tone2Scale = 0; rfScale = 1
  passive_compression_03: HW09_Mixers/passive_tb/schematic, simulator spectre
    Variables: pinDbm = -35; fRF = 5800000000.0; fRF2 = 5800000000.0; tone2Scale = 0; rfScale = 1
  passive_compression_04: HW09_Mixers/passive_tb/schematic, simulator spectre
    Variables: pinDbm = -30; fRF = 5800000000.0; fRF2 = 5800000000.0; tone2Scale = 0; rfScale = 1
  passive_compression_05: HW09_Mixers/passive_tb/schematic, simulator spectre
    Variables: pinDbm = -25; fRF = 5800000000.0; fRF2 = 5800000000.0; tone2Scale = 0; rfScale = 1
  passive_compression_06: HW09_Mixers/passive_tb/schematic, simulator spectre
    Variables: pinDbm = -20; fRF = 5800000000.0; fRF2 = 5800000000.0; tone2Scale = 0; rfScale = 1
  passive_compression_07: HW09_Mixers/passive_tb/schematic, simulator spectre
    Variables: pinDbm = -17.5; fRF = 5800000000.0; fRF2 = 5800000000.0; tone2Scale = 0; rfScale = 1
  passive_compression_08: HW09_Mixers/passive_tb/schematic, simulator spectre
    Variables: pinDbm = -16.25; fRF = 5800000000.0; fRF2 = 5800000000.0; tone2Scale = 0; rfScale = 1
  passive_compression_09: HW09_Mixers/passive_tb/schematic, simulator spectre
    Variables: pinDbm = -15.625; fRF = 5800000000.0; fRF2 = 5800000000.0; tone2Scale = 0; rfScale = 1
  passive_compression_10: HW09_Mixers/passive_tb/schematic, simulator spectre
    Variables: pinDbm = -15.46875; fRF = 5800000000.0; fRF2 = 5800000000.0; tone2Scale = 0; rfScale = 1
  passive_compression_11: HW09_Mixers/passive_tb/schematic, simulator spectre
    Variables: pinDbm = -15.15625; fRF = 5800000000.0; fRF2 = 5800000000.0; tone2Scale = 0; rfScale = 1
  passive_compression_12: HW09_Mixers/passive_tb/schematic, simulator spectre
    Variables: pinDbm = -15; fRF = 5800000000.0; fRF2 = 5800000000.0; tone2Scale = 0; rfScale = 1
  passive_compression_13: HW09_Mixers/passive_tb/schematic, simulator spectre
    Variables: pinDbm = -10; fRF = 5800000000.0; fRF2 = 5800000000.0; tone2Scale = 0; rfScale = 1
  passive_two_tone_00: HW09_Mixers/passive_tb/schematic, simulator spectre
    Variables: pinDbm = -50; fRF = 5790000000.0; fRF2 = 5810000000.0; tone2Scale = 1; rfScale = 1
  passive_two_tone_01: HW09_Mixers/passive_tb/schematic, simulator spectre
    Variables: pinDbm = -45; fRF = 5790000000.0; fRF2 = 5810000000.0; tone2Scale = 1; rfScale = 1
  passive_two_tone_02: HW09_Mixers/passive_tb/schematic, simulator spectre
    Variables: pinDbm = -40; fRF = 5790000000.0; fRF2 = 5810000000.0; tone2Scale = 1; rfScale = 1
  passive_two_tone_03: HW09_Mixers/passive_tb/schematic, simulator spectre
    Variables: pinDbm = -35; fRF = 5790000000.0; fRF2 = 5810000000.0; tone2Scale = 1; rfScale = 1
  passive_two_tone_04: HW09_Mixers/passive_tb/schematic, simulator spectre
    Variables: pinDbm = -30; fRF = 5790000000.0; fRF2 = 5810000000.0; tone2Scale = 1; rfScale = 1
  passive_two_tone_05: HW09_Mixers/passive_tb/schematic, simulator spectre
    Variables: pinDbm = -25; fRF = 5790000000.0; fRF2 = 5810000000.0; tone2Scale = 1; rfScale = 1
  passive_two_tone_06: HW09_Mixers/passive_tb/schematic, simulator spectre
    Variables: pinDbm = -20; fRF = 5790000000.0; fRF2 = 5810000000.0; tone2Scale = 1; rfScale = 1
  passive_two_tone_tight: HW09_Mixers/passive_tb/schematic, simulator spectre
    Variables: pinDbm = -35; fRF = 5790000000.0; fRF2 = 5810000000.0; tone2Scale = 1; rfScale = 1
  active_noise_sb15: HW09_Mixers/active_tb/schematic, simulator spectre
    Variables: pinDbm = -55; fRF = 5800000000.0; fRF2 = 5800000000.0; rfScale = 0; tone2Scale = 0
  active_noise_sb31: HW09_Mixers/active_tb/schematic, simulator spectre
    Variables: pinDbm = -55; fRF = 5800000000.0; fRF2 = 5800000000.0; rfScale = 0; tone2Scale = 0
  active_noise_sb63: HW09_Mixers/active_tb/schematic, simulator spectre
    Variables: pinDbm = -55; fRF = 5800000000.0; fRF2 = 5800000000.0; rfScale = 0; tone2Scale = 0
  active_noise_image: HW09_Mixers/active_tb/schematic, simulator spectre
    Variables: pinDbm = -55; fRF = 5800000000.0; fRF2 = 5800000000.0; rfScale = 0; tone2Scale = 0
  passive_noise_sb15: HW09_Mixers/passive_tb/schematic, simulator spectre
    Variables: pinDbm = -55; fRF = 5800000000.0; fRF2 = 5800000000.0; rfScale = 0; tone2Scale = 0
  passive_noise_sb31: HW09_Mixers/passive_tb/schematic, simulator spectre
    Variables: pinDbm = -55; fRF = 5800000000.0; fRF2 = 5800000000.0; rfScale = 0; tone2Scale = 0
  passive_noise_sb63: HW09_Mixers/passive_tb/schematic, simulator spectre
    Variables: pinDbm = -55; fRF = 5800000000.0; fRF2 = 5800000000.0; rfScale = 0; tone2Scale = 0
  passive_noise_image: HW09_Mixers/passive_tb/schematic, simulator spectre
    Variables: pinDbm = -55; fRF = 5800000000.0; fRF2 = 5800000000.0; rfScale = 0; tone2Scale = 0
