ADE simulation setup
Test active_probe: HW09_Mixers/active_tb/schematic, simulator spectre
  Temperature: 27
Test active_single_tone: HW09_Mixers/active_tb/schematic, simulator spectre
  Models: /tools/designkits/NCSU/FreePDK4514/ncsu_basekit/models/hspice/tran_models/models_nom/NMOS_VTH.inc
  Variables: rfScale = 1; tone2Scale = 0; fRF2 = 5800000000.0; fRF = 5800000000.0; pinDbm = -55
  Temperature: 27
  Simulator options: reltol=1e-5 vabstol=1e-9 iabstol=1e-13
  Analysis tran: stop=2.5e-08 errpreset=conservative maxstep=2p strobeperiod=5p
  Signals: /rf as rf, /rfdrive as rfdrive, /outp as outp, /outn as outn, /lop as lop, /lon as lon, /tail as tail, /VDD/PLUS (terminal) as vdd_current
Test passive_single_tone: HW09_Mixers/passive_tb/schematic, simulator spectre
  Models: /tools/designkits/NCSU/FreePDK4514/ncsu_basekit/models/hspice/tran_models/models_nom/NMOS_VTH.inc
  Variables: rfScale = 1; tone2Scale = 0; fRF2 = 5800000000.0; fRF = 5800000000.0; pinDbm = -55
  Temperature: 27
  Simulator options: reltol=1e-5 vabstol=1e-9 iabstol=1e-13
  Analysis tran: stop=2.5e-08 errpreset=conservative maxstep=2p strobeperiod=5p
  Signals: /rf as rf, /rfdrive as rfdrive, /outp as outp, /outn as outn, /lop as lop, /lon as lon
Test active_noise_sb63: HW09_Mixers/active_tb/schematic, simulator spectre
  Models: /tools/designkits/NCSU/FreePDK4514/ncsu_basekit/models/hspice/tran_models/models_nom/NMOS_VTH.inc
  Variables: tone2Scale = 0; rfScale = 0; fRF2 = 5800000000.0; fRF = 5800000000.0; pinDbm = -55
  Temperature: 27
  Simulator options: reltol=1e-5 vabstol=1e-9 iabstol=1e-13
  Analysis pss: engine=Shooting fund=5.6G harms=63 tstab=5n errpreset=conservative method=gear2only
  Analysis pac: start=5.7G stop=5.9G step=100M sweeptype=absolute maxsideband=1
  Analysis pnoise: start=100M stop=300M step=100M p=/outp n=/outn iprobe=/RFPORT sweeptype=absolute maxsideband=63 refsideband=1 noisetype=timeaverage
  Signals: /rf as rf, /rfdrive as rfdrive, /outp as outp, /outn as outn, /lop as lop, /lon as lon, /tail as tail, /VDD/PLUS (terminal) as vdd_current
Test passive_noise_sb63: HW09_Mixers/passive_tb/schematic, simulator spectre
  Models: /tools/designkits/NCSU/FreePDK4514/ncsu_basekit/models/hspice/tran_models/models_nom/NMOS_VTH.inc
  Variables: tone2Scale = 0; rfScale = 0; fRF2 = 5800000000.0; fRF = 5800000000.0; pinDbm = -55
  Temperature: 27
  Simulator options: reltol=1e-5 vabstol=1e-9 iabstol=1e-13
  Analysis pss: engine=Shooting fund=5.6G harms=63 tstab=5n errpreset=conservative method=gear2only
  Analysis pac: start=5.7G stop=5.9G step=100M sweeptype=absolute maxsideband=1
  Analysis pnoise: start=100M stop=300M step=100M p=/outp n=/outn iprobe=/RFPORT sweeptype=absolute maxsideband=63 refsideband=1 noisetype=timeaverage
  Signals: /rf as rf, /rfdrive as rfdrive, /outp as outp, /outn as outn, /lop as lop, /lon as lon
Test active_single_window_check: HW09_Mixers/active_tb/schematic, simulator spectre
  Models: /tools/designkits/NCSU/FreePDK4514/ncsu_basekit/models/hspice/tran_models/models_nom/NMOS_VTH.inc
  Variables: rfScale = 1; tone2Scale = 0; fRF2 = 5800000000.0; fRF = 5800000000.0; pinDbm = -55
  Temperature: 27
  Simulator options: reltol=1e-5 vabstol=1e-9 iabstol=1e-13
  Analysis tran: stop=1.2e-07 errpreset=conservative maxstep=2p strobeperiod=5p
  Signals: /rf as rf, /rfdrive as rfdrive, /outp as outp, /outn as outn, /lop as lop, /lon as lon, /tail as tail, /VDD/PLUS (terminal) as vdd_current
Test active_compression_00: HW09_Mixers/active_tb/schematic, simulator spectre
  Models: /tools/designkits/NCSU/FreePDK4514/ncsu_basekit/models/hspice/tran_models/models_nom/NMOS_VTH.inc
  Variables: rfScale = 1; tone2Scale = 0; fRF2 = 5800000000.0; fRF = 5800000000.0; pinDbm = -60
  Temperature: 27
  Simulator options: reltol=1e-5 vabstol=1e-9 iabstol=1e-13
  Analysis tran: stop=2.5e-08 errpreset=conservative maxstep=2p strobeperiod=5p
  Signals: /rf as rf, /rfdrive as rfdrive, /outp as outp, /outn as outn, /lop as lop, /lon as lon, /tail as tail, /VDD/PLUS (terminal) as vdd_current
Test active_compression_01: HW09_Mixers/active_tb/schematic, simulator spectre
  Models: /tools/designkits/NCSU/FreePDK4514/ncsu_basekit/models/hspice/tran_models/models_nom/NMOS_VTH.inc
  Variables: rfScale = 1; tone2Scale = 0; fRF2 = 5800000000.0; fRF = 5800000000.0; pinDbm = -50
  Temperature: 27
  Simulator options: reltol=1e-5 vabstol=1e-9 iabstol=1e-13
  Analysis tran: stop=2.5e-08 errpreset=conservative maxstep=2p strobeperiod=5p
  Signals: /rf as rf, /rfdrive as rfdrive, /outp as outp, /outn as outn, /lop as lop, /lon as lon, /tail as tail, /VDD/PLUS (terminal) as vdd_current
Test active_compression_02: HW09_Mixers/active_tb/schematic, simulator spectre
  Models: /tools/designkits/NCSU/FreePDK4514/ncsu_basekit/models/hspice/tran_models/models_nom/NMOS_VTH.inc
  Variables: rfScale = 1; tone2Scale = 0; fRF2 = 5800000000.0; fRF = 5800000000.0; pinDbm = -40
  Temperature: 27
  Simulator options: reltol=1e-5 vabstol=1e-9 iabstol=1e-13
  Analysis tran: stop=2.5e-08 errpreset=conservative maxstep=2p strobeperiod=5p
  Signals: /rf as rf, /rfdrive as rfdrive, /outp as outp, /outn as outn, /lop as lop, /lon as lon, /tail as tail, /VDD/PLUS (terminal) as vdd_current
Test active_compression_03: HW09_Mixers/active_tb/schematic, simulator spectre
  Models: /tools/designkits/NCSU/FreePDK4514/ncsu_basekit/models/hspice/tran_models/models_nom/NMOS_VTH.inc
  Variables: rfScale = 1; tone2Scale = 0; fRF2 = 5800000000.0; fRF = 5800000000.0; pinDbm = -35
  Temperature: 27
  Simulator options: reltol=1e-5 vabstol=1e-9 iabstol=1e-13
  Analysis tran: stop=2.5e-08 errpreset=conservative maxstep=2p strobeperiod=5p
  Signals: /rf as rf, /rfdrive as rfdrive, /outp as outp, /outn as outn, /lop as lop, /lon as lon, /tail as tail, /VDD/PLUS (terminal) as vdd_current
Test active_compression_04: HW09_Mixers/active_tb/schematic, simulator spectre
  Models: /tools/designkits/NCSU/FreePDK4514/ncsu_basekit/models/hspice/tran_models/models_nom/NMOS_VTH.inc
  Variables: rfScale = 1; tone2Scale = 0; fRF2 = 5800000000.0; fRF = 5800000000.0; pinDbm = -30
  Temperature: 27
  Simulator options: reltol=1e-5 vabstol=1e-9 iabstol=1e-13
  Analysis tran: stop=2.5e-08 errpreset=conservative maxstep=2p strobeperiod=5p
  Signals: /rf as rf, /rfdrive as rfdrive, /outp as outp, /outn as outn, /lop as lop, /lon as lon, /tail as tail, /VDD/PLUS (terminal) as vdd_current
Test active_compression_05: HW09_Mixers/active_tb/schematic, simulator spectre
  Models: /tools/designkits/NCSU/FreePDK4514/ncsu_basekit/models/hspice/tran_models/models_nom/NMOS_VTH.inc
  Variables: rfScale = 1; tone2Scale = 0; fRF2 = 5800000000.0; fRF = 5800000000.0; pinDbm = -25
  Temperature: 27
  Simulator options: reltol=1e-5 vabstol=1e-9 iabstol=1e-13
  Analysis tran: stop=2.5e-08 errpreset=conservative maxstep=2p strobeperiod=5p
  Signals: /rf as rf, /rfdrive as rfdrive, /outp as outp, /outn as outn, /lop as lop, /lon as lon, /tail as tail, /VDD/PLUS (terminal) as vdd_current
Test active_compression_06: HW09_Mixers/active_tb/schematic, simulator spectre
  Models: /tools/designkits/NCSU/FreePDK4514/ncsu_basekit/models/hspice/tran_models/models_nom/NMOS_VTH.inc
  Variables: rfScale = 1; tone2Scale = 0; fRF2 = 5800000000.0; fRF = 5800000000.0; pinDbm = -20
  Temperature: 27
  Simulator options: reltol=1e-5 vabstol=1e-9 iabstol=1e-13
  Analysis tran: stop=2.5e-08 errpreset=conservative maxstep=2p strobeperiod=5p
  Signals: /rf as rf, /rfdrive as rfdrive, /outp as outp, /outn as outn, /lop as lop, /lon as lon, /tail as tail, /VDD/PLUS (terminal) as vdd_current
Test active_compression_07: HW09_Mixers/active_tb/schematic, simulator spectre
  Models: /tools/designkits/NCSU/FreePDK4514/ncsu_basekit/models/hspice/tran_models/models_nom/NMOS_VTH.inc
  Variables: rfScale = 1; tone2Scale = 0; fRF2 = 5800000000.0; fRF = 5800000000.0; pinDbm = -17.5
  Temperature: 27
  Simulator options: reltol=1e-5 vabstol=1e-9 iabstol=1e-13
  Analysis tran: stop=2.5e-08 errpreset=conservative maxstep=2p strobeperiod=5p
  Signals: /rf as rf, /rfdrive as rfdrive, /outp as outp, /outn as outn, /lop as lop, /lon as lon, /tail as tail, /VDD/PLUS (terminal) as vdd_current
Test active_compression_08: HW09_Mixers/active_tb/schematic, simulator spectre
  Models: /tools/designkits/NCSU/FreePDK4514/ncsu_basekit/models/hspice/tran_models/models_nom/NMOS_VTH.inc
  Variables: rfScale = 1; tone2Scale = 0; fRF2 = 5800000000.0; fRF = 5800000000.0; pinDbm = -16.25
  Temperature: 27
  Simulator options: reltol=1e-5 vabstol=1e-9 iabstol=1e-13
  Analysis tran: stop=2.5e-08 errpreset=conservative maxstep=2p strobeperiod=5p
  Signals: /rf as rf, /rfdrive as rfdrive, /outp as outp, /outn as outn, /lop as lop, /lon as lon, /tail as tail, /VDD/PLUS (terminal) as vdd_current
Test active_compression_09: HW09_Mixers/active_tb/schematic, simulator spectre
  Models: /tools/designkits/NCSU/FreePDK4514/ncsu_basekit/models/hspice/tran_models/models_nom/NMOS_VTH.inc
  Variables: rfScale = 1; tone2Scale = 0; fRF2 = 5800000000.0; fRF = 5800000000.0; pinDbm = -15.625
  Temperature: 27
  Simulator options: reltol=1e-5 vabstol=1e-9 iabstol=1e-13
  Analysis tran: stop=2.5e-08 errpreset=conservative maxstep=2p strobeperiod=5p
  Signals: /rf as rf, /rfdrive as rfdrive, /outp as outp, /outn as outn, /lop as lop, /lon as lon, /tail as tail, /VDD/PLUS (terminal) as vdd_current
Test active_compression_10: HW09_Mixers/active_tb/schematic, simulator spectre
  Models: /tools/designkits/NCSU/FreePDK4514/ncsu_basekit/models/hspice/tran_models/models_nom/NMOS_VTH.inc
  Variables: rfScale = 1; tone2Scale = 0; fRF2 = 5800000000.0; fRF = 5800000000.0; pinDbm = -15.46875
  Temperature: 27
  Simulator options: reltol=1e-5 vabstol=1e-9 iabstol=1e-13
  Analysis tran: stop=2.5e-08 errpreset=conservative maxstep=2p strobeperiod=5p
  Signals: /rf as rf, /rfdrive as rfdrive, /outp as outp, /outn as outn, /lop as lop, /lon as lon, /tail as tail, /VDD/PLUS (terminal) as vdd_current
Test active_compression_11: HW09_Mixers/active_tb/schematic, simulator spectre
  Models: /tools/designkits/NCSU/FreePDK4514/ncsu_basekit/models/hspice/tran_models/models_nom/NMOS_VTH.inc
  Variables: rfScale = 1; tone2Scale = 0; fRF2 = 5800000000.0; fRF = 5800000000.0; pinDbm = -15.15625
  Temperature: 27
  Simulator options: reltol=1e-5 vabstol=1e-9 iabstol=1e-13
  Analysis tran: stop=2.5e-08 errpreset=conservative maxstep=2p strobeperiod=5p
  Signals: /rf as rf, /rfdrive as rfdrive, /outp as outp, /outn as outn, /lop as lop, /lon as lon, /tail as tail, /VDD/PLUS (terminal) as vdd_current
Test active_compression_12: HW09_Mixers/active_tb/schematic, simulator spectre
  Models: /tools/designkits/NCSU/FreePDK4514/ncsu_basekit/models/hspice/tran_models/models_nom/NMOS_VTH.inc
  Variables: rfScale = 1; tone2Scale = 0; fRF2 = 5800000000.0; fRF = 5800000000.0; pinDbm = -15
  Temperature: 27
  Simulator options: reltol=1e-5 vabstol=1e-9 iabstol=1e-13
  Analysis tran: stop=2.5e-08 errpreset=conservative maxstep=2p strobeperiod=5p
  Signals: /rf as rf, /rfdrive as rfdrive, /outp as outp, /outn as outn, /lop as lop, /lon as lon, /tail as tail, /VDD/PLUS (terminal) as vdd_current
Test active_compression_13: HW09_Mixers/active_tb/schematic, simulator spectre
  Models: /tools/designkits/NCSU/FreePDK4514/ncsu_basekit/models/hspice/tran_models/models_nom/NMOS_VTH.inc
  Variables: rfScale = 1; tone2Scale = 0; fRF2 = 5800000000.0; fRF = 5800000000.0; pinDbm = -10
  Temperature: 27
  Simulator options: reltol=1e-5 vabstol=1e-9 iabstol=1e-13
  Analysis tran: stop=2.5e-08 errpreset=conservative maxstep=2p strobeperiod=5p
  Signals: /rf as rf, /rfdrive as rfdrive, /outp as outp, /outn as outn, /lop as lop, /lon as lon, /tail as tail, /VDD/PLUS (terminal) as vdd_current
Test active_two_tone_00: HW09_Mixers/active_tb/schematic, simulator spectre
  Models: /tools/designkits/NCSU/FreePDK4514/ncsu_basekit/models/hspice/tran_models/models_nom/NMOS_VTH.inc
  Variables: rfScale = 1; tone2Scale = 1; fRF2 = 5810000000.0; fRF = 5790000000.0; pinDbm = -50
  Temperature: 27
  Simulator options: reltol=1e-5 vabstol=1e-9 iabstol=1e-13
  Analysis tran: stop=1.2e-07 errpreset=conservative maxstep=2p strobeperiod=5p
  Signals: /rf as rf, /rfdrive as rfdrive, /outp as outp, /outn as outn, /lop as lop, /lon as lon, /tail as tail, /VDD/PLUS (terminal) as vdd_current
Test active_two_tone_01: HW09_Mixers/active_tb/schematic, simulator spectre
  Models: /tools/designkits/NCSU/FreePDK4514/ncsu_basekit/models/hspice/tran_models/models_nom/NMOS_VTH.inc
  Variables: rfScale = 1; tone2Scale = 1; fRF2 = 5810000000.0; fRF = 5790000000.0; pinDbm = -45
  Temperature: 27
  Simulator options: reltol=1e-5 vabstol=1e-9 iabstol=1e-13
  Analysis tran: stop=1.2e-07 errpreset=conservative maxstep=2p strobeperiod=5p
  Signals: /rf as rf, /rfdrive as rfdrive, /outp as outp, /outn as outn, /lop as lop, /lon as lon, /tail as tail, /VDD/PLUS (terminal) as vdd_current
Test active_two_tone_02: HW09_Mixers/active_tb/schematic, simulator spectre
  Models: /tools/designkits/NCSU/FreePDK4514/ncsu_basekit/models/hspice/tran_models/models_nom/NMOS_VTH.inc
  Variables: rfScale = 1; tone2Scale = 1; fRF2 = 5810000000.0; fRF = 5790000000.0; pinDbm = -40
  Temperature: 27
  Simulator options: reltol=1e-5 vabstol=1e-9 iabstol=1e-13
  Analysis tran: stop=1.2e-07 errpreset=conservative maxstep=2p strobeperiod=5p
  Signals: /rf as rf, /rfdrive as rfdrive, /outp as outp, /outn as outn, /lop as lop, /lon as lon, /tail as tail, /VDD/PLUS (terminal) as vdd_current
Test active_two_tone_03: HW09_Mixers/active_tb/schematic, simulator spectre
  Models: /tools/designkits/NCSU/FreePDK4514/ncsu_basekit/models/hspice/tran_models/models_nom/NMOS_VTH.inc
  Variables: rfScale = 1; tone2Scale = 1; fRF2 = 5810000000.0; fRF = 5790000000.0; pinDbm = -35
  Temperature: 27
  Simulator options: reltol=1e-5 vabstol=1e-9 iabstol=1e-13
  Analysis tran: stop=1.2e-07 errpreset=conservative maxstep=2p strobeperiod=5p
  Signals: /rf as rf, /rfdrive as rfdrive, /outp as outp, /outn as outn, /lop as lop, /lon as lon, /tail as tail, /VDD/PLUS (terminal) as vdd_current
Test active_two_tone_04: HW09_Mixers/active_tb/schematic, simulator spectre
  Models: /tools/designkits/NCSU/FreePDK4514/ncsu_basekit/models/hspice/tran_models/models_nom/NMOS_VTH.inc
  Variables: rfScale = 1; tone2Scale = 1; fRF2 = 5810000000.0; fRF = 5790000000.0; pinDbm = -30
  Temperature: 27
  Simulator options: reltol=1e-5 vabstol=1e-9 iabstol=1e-13
  Analysis tran: stop=1.2e-07 errpreset=conservative maxstep=2p strobeperiod=5p
  Signals: /rf as rf, /rfdrive as rfdrive, /outp as outp, /outn as outn, /lop as lop, /lon as lon, /tail as tail, /VDD/PLUS (terminal) as vdd_current
Test active_two_tone_05: HW09_Mixers/active_tb/schematic, simulator spectre
  Models: /tools/designkits/NCSU/FreePDK4514/ncsu_basekit/models/hspice/tran_models/models_nom/NMOS_VTH.inc
  Variables: rfScale = 1; tone2Scale = 1; fRF2 = 5810000000.0; fRF = 5790000000.0; pinDbm = -25
  Temperature: 27
  Simulator options: reltol=1e-5 vabstol=1e-9 iabstol=1e-13
  Analysis tran: stop=1.2e-07 errpreset=conservative maxstep=2p strobeperiod=5p
  Signals: /rf as rf, /rfdrive as rfdrive, /outp as outp, /outn as outn, /lop as lop, /lon as lon, /tail as tail, /VDD/PLUS (terminal) as vdd_current
Test active_two_tone_06: HW09_Mixers/active_tb/schematic, simulator spectre
  Models: /tools/designkits/NCSU/FreePDK4514/ncsu_basekit/models/hspice/tran_models/models_nom/NMOS_VTH.inc
  Variables: rfScale = 1; tone2Scale = 1; fRF2 = 5810000000.0; fRF = 5790000000.0; pinDbm = -20
  Temperature: 27
  Simulator options: reltol=1e-5 vabstol=1e-9 iabstol=1e-13
  Analysis tran: stop=1.2e-07 errpreset=conservative maxstep=2p strobeperiod=5p
  Signals: /rf as rf, /rfdrive as rfdrive, /outp as outp, /outn as outn, /lop as lop, /lon as lon, /tail as tail, /VDD/PLUS (terminal) as vdd_current
Test active_two_tone_tight: HW09_Mixers/active_tb/schematic, simulator spectre
  Models: /tools/designkits/NCSU/FreePDK4514/ncsu_basekit/models/hspice/tran_models/models_nom/NMOS_VTH.inc
  Variables: rfScale = 1; tone2Scale = 1; fRF2 = 5810000000.0; fRF = 5790000000.0; pinDbm = -35
  Temperature: 27
  Simulator options: reltol=1e-6 vabstol=1e-9 iabstol=1e-13
  Analysis tran: stop=1.2e-07 errpreset=conservative maxstep=1p strobeperiod=5p
  Signals: /rf as rf, /rfdrive as rfdrive, /outp as outp, /outn as outn, /lop as lop, /lon as lon, /tail as tail, /VDD/PLUS (terminal) as vdd_current
Test passive_single_window_check: HW09_Mixers/passive_tb/schematic, simulator spectre
  Models: /tools/designkits/NCSU/FreePDK4514/ncsu_basekit/models/hspice/tran_models/models_nom/NMOS_VTH.inc
  Variables: rfScale = 1; tone2Scale = 0; fRF2 = 5800000000.0; fRF = 5800000000.0; pinDbm = -55
  Temperature: 27
  Simulator options: reltol=1e-5 vabstol=1e-9 iabstol=1e-13
  Analysis tran: stop=1.2e-07 errpreset=conservative maxstep=2p strobeperiod=5p
  Signals: /rf as rf, /rfdrive as rfdrive, /outp as outp, /outn as outn, /lop as lop, /lon as lon
Test passive_compression_00: HW09_Mixers/passive_tb/schematic, simulator spectre
  Models: /tools/designkits/NCSU/FreePDK4514/ncsu_basekit/models/hspice/tran_models/models_nom/NMOS_VTH.inc
  Variables: rfScale = 1; tone2Scale = 0; fRF2 = 5800000000.0; fRF = 5800000000.0; pinDbm = -60
  Temperature: 27
  Simulator options: reltol=1e-5 vabstol=1e-9 iabstol=1e-13
  Analysis tran: stop=2.5e-08 errpreset=conservative maxstep=2p strobeperiod=5p
  Signals: /rf as rf, /rfdrive as rfdrive, /outp as outp, /outn as outn, /lop as lop, /lon as lon
Test passive_compression_01: HW09_Mixers/passive_tb/schematic, simulator spectre
  Models: /tools/designkits/NCSU/FreePDK4514/ncsu_basekit/models/hspice/tran_models/models_nom/NMOS_VTH.inc
  Variables: rfScale = 1; tone2Scale = 0; fRF2 = 5800000000.0; fRF = 5800000000.0; pinDbm = -50
  Temperature: 27
  Simulator options: reltol=1e-5 vabstol=1e-9 iabstol=1e-13
  Analysis tran: stop=2.5e-08 errpreset=conservative maxstep=2p strobeperiod=5p
  Signals: /rf as rf, /rfdrive as rfdrive, /outp as outp, /outn as outn, /lop as lop, /lon as lon
Test passive_compression_02: HW09_Mixers/passive_tb/schematic, simulator spectre
  Models: /tools/designkits/NCSU/FreePDK4514/ncsu_basekit/models/hspice/tran_models/models_nom/NMOS_VTH.inc
  Variables: rfScale = 1; tone2Scale = 0; fRF2 = 5800000000.0; fRF = 5800000000.0; pinDbm = -40
  Temperature: 27
  Simulator options: reltol=1e-5 vabstol=1e-9 iabstol=1e-13
  Analysis tran: stop=2.5e-08 errpreset=conservative maxstep=2p strobeperiod=5p
  Signals: /rf as rf, /rfdrive as rfdrive, /outp as outp, /outn as outn, /lop as lop, /lon as lon
Test passive_compression_03: HW09_Mixers/passive_tb/schematic, simulator spectre
  Models: /tools/designkits/NCSU/FreePDK4514/ncsu_basekit/models/hspice/tran_models/models_nom/NMOS_VTH.inc
  Variables: rfScale = 1; tone2Scale = 0; fRF2 = 5800000000.0; fRF = 5800000000.0; pinDbm = -35
  Temperature: 27
  Simulator options: reltol=1e-5 vabstol=1e-9 iabstol=1e-13
  Analysis tran: stop=2.5e-08 errpreset=conservative maxstep=2p strobeperiod=5p
  Signals: /rf as rf, /rfdrive as rfdrive, /outp as outp, /outn as outn, /lop as lop, /lon as lon
Test passive_compression_04: HW09_Mixers/passive_tb/schematic, simulator spectre
  Models: /tools/designkits/NCSU/FreePDK4514/ncsu_basekit/models/hspice/tran_models/models_nom/NMOS_VTH.inc
  Variables: rfScale = 1; tone2Scale = 0; fRF2 = 5800000000.0; fRF = 5800000000.0; pinDbm = -30
  Temperature: 27
  Simulator options: reltol=1e-5 vabstol=1e-9 iabstol=1e-13
  Analysis tran: stop=2.5e-08 errpreset=conservative maxstep=2p strobeperiod=5p
  Signals: /rf as rf, /rfdrive as rfdrive, /outp as outp, /outn as outn, /lop as lop, /lon as lon
Test passive_compression_05: HW09_Mixers/passive_tb/schematic, simulator spectre
  Models: /tools/designkits/NCSU/FreePDK4514/ncsu_basekit/models/hspice/tran_models/models_nom/NMOS_VTH.inc
  Variables: rfScale = 1; tone2Scale = 0; fRF2 = 5800000000.0; fRF = 5800000000.0; pinDbm = -25
  Temperature: 27
  Simulator options: reltol=1e-5 vabstol=1e-9 iabstol=1e-13
  Analysis tran: stop=2.5e-08 errpreset=conservative maxstep=2p strobeperiod=5p
  Signals: /rf as rf, /rfdrive as rfdrive, /outp as outp, /outn as outn, /lop as lop, /lon as lon
Test passive_compression_06: HW09_Mixers/passive_tb/schematic, simulator spectre
  Models: /tools/designkits/NCSU/FreePDK4514/ncsu_basekit/models/hspice/tran_models/models_nom/NMOS_VTH.inc
  Variables: rfScale = 1; tone2Scale = 0; fRF2 = 5800000000.0; fRF = 5800000000.0; pinDbm = -20
  Temperature: 27
  Simulator options: reltol=1e-5 vabstol=1e-9 iabstol=1e-13
  Analysis tran: stop=2.5e-08 errpreset=conservative maxstep=2p strobeperiod=5p
  Signals: /rf as rf, /rfdrive as rfdrive, /outp as outp, /outn as outn, /lop as lop, /lon as lon
Test passive_compression_07: HW09_Mixers/passive_tb/schematic, simulator spectre
  Models: /tools/designkits/NCSU/FreePDK4514/ncsu_basekit/models/hspice/tran_models/models_nom/NMOS_VTH.inc
  Variables: rfScale = 1; tone2Scale = 0; fRF2 = 5800000000.0; fRF = 5800000000.0; pinDbm = -17.5
  Temperature: 27
  Simulator options: reltol=1e-5 vabstol=1e-9 iabstol=1e-13
  Analysis tran: stop=2.5e-08 errpreset=conservative maxstep=2p strobeperiod=5p
  Signals: /rf as rf, /rfdrive as rfdrive, /outp as outp, /outn as outn, /lop as lop, /lon as lon
Test passive_compression_08: HW09_Mixers/passive_tb/schematic, simulator spectre
  Models: /tools/designkits/NCSU/FreePDK4514/ncsu_basekit/models/hspice/tran_models/models_nom/NMOS_VTH.inc
  Variables: rfScale = 1; tone2Scale = 0; fRF2 = 5800000000.0; fRF = 5800000000.0; pinDbm = -16.25
  Temperature: 27
  Simulator options: reltol=1e-5 vabstol=1e-9 iabstol=1e-13
  Analysis tran: stop=2.5e-08 errpreset=conservative maxstep=2p strobeperiod=5p
  Signals: /rf as rf, /rfdrive as rfdrive, /outp as outp, /outn as outn, /lop as lop, /lon as lon
Test passive_compression_09: HW09_Mixers/passive_tb/schematic, simulator spectre
  Models: /tools/designkits/NCSU/FreePDK4514/ncsu_basekit/models/hspice/tran_models/models_nom/NMOS_VTH.inc
  Variables: rfScale = 1; tone2Scale = 0; fRF2 = 5800000000.0; fRF = 5800000000.0; pinDbm = -15.625
  Temperature: 27
  Simulator options: reltol=1e-5 vabstol=1e-9 iabstol=1e-13
  Analysis tran: stop=2.5e-08 errpreset=conservative maxstep=2p strobeperiod=5p
  Signals: /rf as rf, /rfdrive as rfdrive, /outp as outp, /outn as outn, /lop as lop, /lon as lon
Test passive_compression_10: HW09_Mixers/passive_tb/schematic, simulator spectre
  Models: /tools/designkits/NCSU/FreePDK4514/ncsu_basekit/models/hspice/tran_models/models_nom/NMOS_VTH.inc
  Variables: rfScale = 1; tone2Scale = 0; fRF2 = 5800000000.0; fRF = 5800000000.0; pinDbm = -15.46875
  Temperature: 27
  Simulator options: reltol=1e-5 vabstol=1e-9 iabstol=1e-13
  Analysis tran: stop=2.5e-08 errpreset=conservative maxstep=2p strobeperiod=5p
  Signals: /rf as rf, /rfdrive as rfdrive, /outp as outp, /outn as outn, /lop as lop, /lon as lon
Test passive_compression_11: HW09_Mixers/passive_tb/schematic, simulator spectre
  Models: /tools/designkits/NCSU/FreePDK4514/ncsu_basekit/models/hspice/tran_models/models_nom/NMOS_VTH.inc
  Variables: rfScale = 1; tone2Scale = 0; fRF2 = 5800000000.0; fRF = 5800000000.0; pinDbm = -15.15625
  Temperature: 27
  Simulator options: reltol=1e-5 vabstol=1e-9 iabstol=1e-13
  Analysis tran: stop=2.5e-08 errpreset=conservative maxstep=2p strobeperiod=5p
  Signals: /rf as rf, /rfdrive as rfdrive, /outp as outp, /outn as outn, /lop as lop, /lon as lon
Test passive_compression_12: HW09_Mixers/passive_tb/schematic, simulator spectre
  Models: /tools/designkits/NCSU/FreePDK4514/ncsu_basekit/models/hspice/tran_models/models_nom/NMOS_VTH.inc
  Variables: rfScale = 1; tone2Scale = 0; fRF2 = 5800000000.0; fRF = 5800000000.0; pinDbm = -15
  Temperature: 27
  Simulator options: reltol=1e-5 vabstol=1e-9 iabstol=1e-13
  Analysis tran: stop=2.5e-08 errpreset=conservative maxstep=2p strobeperiod=5p
  Signals: /rf as rf, /rfdrive as rfdrive, /outp as outp, /outn as outn, /lop as lop, /lon as lon
Test passive_compression_13: HW09_Mixers/passive_tb/schematic, simulator spectre
  Models: /tools/designkits/NCSU/FreePDK4514/ncsu_basekit/models/hspice/tran_models/models_nom/NMOS_VTH.inc
  Variables: rfScale = 1; tone2Scale = 0; fRF2 = 5800000000.0; fRF = 5800000000.0; pinDbm = -10
  Temperature: 27
  Simulator options: reltol=1e-5 vabstol=1e-9 iabstol=1e-13
  Analysis tran: stop=2.5e-08 errpreset=conservative maxstep=2p strobeperiod=5p
  Signals: /rf as rf, /rfdrive as rfdrive, /outp as outp, /outn as outn, /lop as lop, /lon as lon
Test passive_two_tone_00: HW09_Mixers/passive_tb/schematic, simulator spectre
  Models: /tools/designkits/NCSU/FreePDK4514/ncsu_basekit/models/hspice/tran_models/models_nom/NMOS_VTH.inc
  Variables: rfScale = 1; tone2Scale = 1; fRF2 = 5810000000.0; fRF = 5790000000.0; pinDbm = -50
  Temperature: 27
  Simulator options: reltol=1e-5 vabstol=1e-9 iabstol=1e-13
  Analysis tran: stop=1.2e-07 errpreset=conservative maxstep=2p strobeperiod=5p
  Signals: /rf as rf, /rfdrive as rfdrive, /outp as outp, /outn as outn, /lop as lop, /lon as lon
Test passive_two_tone_01: HW09_Mixers/passive_tb/schematic, simulator spectre
  Models: /tools/designkits/NCSU/FreePDK4514/ncsu_basekit/models/hspice/tran_models/models_nom/NMOS_VTH.inc
  Variables: rfScale = 1; tone2Scale = 1; fRF2 = 5810000000.0; fRF = 5790000000.0; pinDbm = -45
  Temperature: 27
  Simulator options: reltol=1e-5 vabstol=1e-9 iabstol=1e-13
  Analysis tran: stop=1.2e-07 errpreset=conservative maxstep=2p strobeperiod=5p
  Signals: /rf as rf, /rfdrive as rfdrive, /outp as outp, /outn as outn, /lop as lop, /lon as lon
Test passive_two_tone_02: HW09_Mixers/passive_tb/schematic, simulator spectre
  Models: /tools/designkits/NCSU/FreePDK4514/ncsu_basekit/models/hspice/tran_models/models_nom/NMOS_VTH.inc
  Variables: rfScale = 1; tone2Scale = 1; fRF2 = 5810000000.0; fRF = 5790000000.0; pinDbm = -40
  Temperature: 27
  Simulator options: reltol=1e-5 vabstol=1e-9 iabstol=1e-13
  Analysis tran: stop=1.2e-07 errpreset=conservative maxstep=2p strobeperiod=5p
  Signals: /rf as rf, /rfdrive as rfdrive, /outp as outp, /outn as outn, /lop as lop, /lon as lon
Test passive_two_tone_03: HW09_Mixers/passive_tb/schematic, simulator spectre
  Models: /tools/designkits/NCSU/FreePDK4514/ncsu_basekit/models/hspice/tran_models/models_nom/NMOS_VTH.inc
  Variables: rfScale = 1; tone2Scale = 1; fRF2 = 5810000000.0; fRF = 5790000000.0; pinDbm = -35
  Temperature: 27
  Simulator options: reltol=1e-5 vabstol=1e-9 iabstol=1e-13
  Analysis tran: stop=1.2e-07 errpreset=conservative maxstep=2p strobeperiod=5p
  Signals: /rf as rf, /rfdrive as rfdrive, /outp as outp, /outn as outn, /lop as lop, /lon as lon
Test passive_two_tone_04: HW09_Mixers/passive_tb/schematic, simulator spectre
  Models: /tools/designkits/NCSU/FreePDK4514/ncsu_basekit/models/hspice/tran_models/models_nom/NMOS_VTH.inc
  Variables: rfScale = 1; tone2Scale = 1; fRF2 = 5810000000.0; fRF = 5790000000.0; pinDbm = -30
  Temperature: 27
  Simulator options: reltol=1e-5 vabstol=1e-9 iabstol=1e-13
  Analysis tran: stop=1.2e-07 errpreset=conservative maxstep=2p strobeperiod=5p
  Signals: /rf as rf, /rfdrive as rfdrive, /outp as outp, /outn as outn, /lop as lop, /lon as lon
Test passive_two_tone_05: HW09_Mixers/passive_tb/schematic, simulator spectre
  Models: /tools/designkits/NCSU/FreePDK4514/ncsu_basekit/models/hspice/tran_models/models_nom/NMOS_VTH.inc
  Variables: rfScale = 1; tone2Scale = 1; fRF2 = 5810000000.0; fRF = 5790000000.0; pinDbm = -25
  Temperature: 27
  Simulator options: reltol=1e-5 vabstol=1e-9 iabstol=1e-13
  Analysis tran: stop=1.2e-07 errpreset=conservative maxstep=2p strobeperiod=5p
  Signals: /rf as rf, /rfdrive as rfdrive, /outp as outp, /outn as outn, /lop as lop, /lon as lon
Test passive_two_tone_06: HW09_Mixers/passive_tb/schematic, simulator spectre
  Models: /tools/designkits/NCSU/FreePDK4514/ncsu_basekit/models/hspice/tran_models/models_nom/NMOS_VTH.inc
  Variables: rfScale = 1; tone2Scale = 1; fRF2 = 5810000000.0; fRF = 5790000000.0; pinDbm = -20
  Temperature: 27
  Simulator options: reltol=1e-5 vabstol=1e-9 iabstol=1e-13
  Analysis tran: stop=1.2e-07 errpreset=conservative maxstep=2p strobeperiod=5p
  Signals: /rf as rf, /rfdrive as rfdrive, /outp as outp, /outn as outn, /lop as lop, /lon as lon
Test passive_two_tone_tight: HW09_Mixers/passive_tb/schematic, simulator spectre
  Models: /tools/designkits/NCSU/FreePDK4514/ncsu_basekit/models/hspice/tran_models/models_nom/NMOS_VTH.inc
  Variables: rfScale = 1; tone2Scale = 1; fRF2 = 5810000000.0; fRF = 5790000000.0; pinDbm = -35
  Temperature: 27
  Simulator options: reltol=1e-6 vabstol=1e-9 iabstol=1e-13
  Analysis tran: stop=1.2e-07 errpreset=conservative maxstep=1p strobeperiod=5p
  Signals: /rf as rf, /rfdrive as rfdrive, /outp as outp, /outn as outn, /lop as lop, /lon as lon
Test active_noise_sb15: HW09_Mixers/active_tb/schematic, simulator spectre
  Models: /tools/designkits/NCSU/FreePDK4514/ncsu_basekit/models/hspice/tran_models/models_nom/NMOS_VTH.inc
  Variables: tone2Scale = 0; rfScale = 0; fRF2 = 5800000000.0; fRF = 5800000000.0; pinDbm = -55
  Temperature: 27
  Simulator options: reltol=1e-5 vabstol=1e-9 iabstol=1e-13
  Analysis pss: engine=Shooting fund=5.6G harms=63 tstab=5n errpreset=conservative method=gear2only
  Analysis pac: start=5.7G stop=5.9G step=100M sweeptype=absolute maxsideband=1
  Analysis pnoise: start=100M stop=300M step=100M p=/outp n=/outn iprobe=/RFPORT sweeptype=absolute maxsideband=15 refsideband=1 noisetype=timeaverage
  Signals: /rf as rf, /rfdrive as rfdrive, /outp as outp, /outn as outn, /lop as lop, /lon as lon, /tail as tail, /VDD/PLUS (terminal) as vdd_current
Test active_noise_sb31: HW09_Mixers/active_tb/schematic, simulator spectre
  Models: /tools/designkits/NCSU/FreePDK4514/ncsu_basekit/models/hspice/tran_models/models_nom/NMOS_VTH.inc
  Variables: tone2Scale = 0; rfScale = 0; fRF2 = 5800000000.0; fRF = 5800000000.0; pinDbm = -55
  Temperature: 27
  Simulator options: reltol=1e-5 vabstol=1e-9 iabstol=1e-13
  Analysis pss: engine=Shooting fund=5.6G harms=63 tstab=5n errpreset=conservative method=gear2only
  Analysis pac: start=5.7G stop=5.9G step=100M sweeptype=absolute maxsideband=1
  Analysis pnoise: start=100M stop=300M step=100M p=/outp n=/outn iprobe=/RFPORT sweeptype=absolute maxsideband=31 refsideband=1 noisetype=timeaverage
  Signals: /rf as rf, /rfdrive as rfdrive, /outp as outp, /outn as outn, /lop as lop, /lon as lon, /tail as tail, /VDD/PLUS (terminal) as vdd_current
Test active_noise_image: HW09_Mixers/active_tb/schematic, simulator spectre
  Models: /tools/designkits/NCSU/FreePDK4514/ncsu_basekit/models/hspice/tran_models/models_nom/NMOS_VTH.inc
  Variables: tone2Scale = 0; rfScale = 0; fRF2 = 5800000000.0; fRF = 5800000000.0; pinDbm = -55
  Temperature: 27
  Simulator options: reltol=1e-5 vabstol=1e-9 iabstol=1e-13
  Analysis pss: engine=Shooting fund=5.6G harms=63 tstab=5n errpreset=conservative method=gear2only
  Analysis pac: start=5.3G stop=5.5G step=100M sweeptype=absolute maxsideband=1
  Signals: /rf as rf, /rfdrive as rfdrive, /outp as outp, /outn as outn, /lop as lop, /lon as lon, /tail as tail, /VDD/PLUS (terminal) as vdd_current
Test passive_noise_sb15: HW09_Mixers/passive_tb/schematic, simulator spectre
  Models: /tools/designkits/NCSU/FreePDK4514/ncsu_basekit/models/hspice/tran_models/models_nom/NMOS_VTH.inc
  Variables: tone2Scale = 0; rfScale = 0; fRF2 = 5800000000.0; fRF = 5800000000.0; pinDbm = -55
  Temperature: 27
  Simulator options: reltol=1e-5 vabstol=1e-9 iabstol=1e-13
  Analysis pss: engine=Shooting fund=5.6G harms=63 tstab=5n errpreset=conservative method=gear2only
  Analysis pac: start=5.7G stop=5.9G step=100M sweeptype=absolute maxsideband=1
  Analysis pnoise: start=100M stop=300M step=100M p=/outp n=/outn iprobe=/RFPORT sweeptype=absolute maxsideband=15 refsideband=1 noisetype=timeaverage
  Signals: /rf as rf, /rfdrive as rfdrive, /outp as outp, /outn as outn, /lop as lop, /lon as lon
Test passive_noise_sb31: HW09_Mixers/passive_tb/schematic, simulator spectre
  Models: /tools/designkits/NCSU/FreePDK4514/ncsu_basekit/models/hspice/tran_models/models_nom/NMOS_VTH.inc
  Variables: tone2Scale = 0; rfScale = 0; fRF2 = 5800000000.0; fRF = 5800000000.0; pinDbm = -55
  Temperature: 27
  Simulator options: reltol=1e-5 vabstol=1e-9 iabstol=1e-13
  Analysis pss: engine=Shooting fund=5.6G harms=63 tstab=5n errpreset=conservative method=gear2only
  Analysis pac: start=5.7G stop=5.9G step=100M sweeptype=absolute maxsideband=1
  Analysis pnoise: start=100M stop=300M step=100M p=/outp n=/outn iprobe=/RFPORT sweeptype=absolute maxsideband=31 refsideband=1 noisetype=timeaverage
  Signals: /rf as rf, /rfdrive as rfdrive, /outp as outp, /outn as outn, /lop as lop, /lon as lon
Test passive_noise_image: HW09_Mixers/passive_tb/schematic, simulator spectre
  Models: /tools/designkits/NCSU/FreePDK4514/ncsu_basekit/models/hspice/tran_models/models_nom/NMOS_VTH.inc
  Variables: tone2Scale = 0; rfScale = 0; fRF2 = 5800000000.0; fRF = 5800000000.0; pinDbm = -55
  Temperature: 27
  Simulator options: reltol=1e-5 vabstol=1e-9 iabstol=1e-13
  Analysis pss: engine=Shooting fund=5.6G harms=63 tstab=5n errpreset=conservative method=gear2only
  Analysis pac: start=5.3G stop=5.5G step=100M sweeptype=absolute maxsideband=1
  Signals: /rf as rf, /rfdrive as rfdrive, /outp as outp, /outn as outn, /lop as lop, /lon as lon
Run mode: Single Run, Sweeps and Corners
Disabled tests: active_probe
