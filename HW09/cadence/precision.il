; Correct native high-performance mode before GUI-driven verification runs.
; Spectre X presets ignore/redefine user accuracy controls; use ordinary Spectre.
; This file updates the existing GUI state and never starts a simulation.
procedure(hw09FocusADEGUI()
  let((sess windowNumber)
    foreach(existing maeGetSessions()
      when(and(equal(axlGetSessionLibName(existing) "HW09_Mixers")
               equal(axlGetSessionCellName(existing) "mixer_campaign")) sess=existing)
    )
    when(sess
      windowNumber=axlGetSessionWindowNumber(sess)
      when(and(numberp(windowNumber) windowNumber>0) hiRaiseWindow(windowNumber t))
    )
  )
)
procedure(hw09FixNativeAccuracy()
  let((sess th reference overrideValue out reltolValue maxstepValue)
    foreach(existing maeGetSessions()
      when(and(equal(axlGetSessionLibName(existing) "HW09_Mixers")
               equal(axlGetSessionCellName(existing) "mixer_campaign")) sess=existing)
    )
    unless(sess error("Open the existing HW09 maestro GUI first.\n"))
    reference=maeGetTestSession("active_single_tone" ?session sess)
    overrideValue=asiGetHighPerformanceOptionVal(reference 'errorLevel)
    envSetVal("spectre.turboOpts" "uniMode" 'string "Spectre")
    out=outfile("/nethome/sjeon84/Gatech-ECE6420/HW09/accuracy_controls_audit.txt")
    fprintf(out "SESSION %L REFERENCE_ERROR_OVERRIDE %L\n" sess overrideValue)
    foreach(testName maeGetSetup(?session sess)
      unless(equal(testName "active_probe")
        th=maeGetTestSession(testName ?session sess)
        asiSetHighPerformanceOptionVal(th 'uniMode "Spectre")
        unless(equal(asiGetHighPerformanceOptionVal(th 'uniMode) "Spectre")
          error("Ordinary Spectre mode was not set for %s.\n" testName))
        when(stringp(overrideValue) asiSetHighPerformanceOptionVal(th 'errorLevel overrideValue))
        reltolValue=if(rexMatchp("tight" testName) "1e-6" "1e-5")
        maxstepValue=if(rexMatchp("tight" testName) "1p" "2p")
        maeSetSimOption(testName ?options list(list("reltol" reltolValue) list("vabstol" "1e-9") list("iabstol" "1e-13") list("gmin" "1e-12") list("temp" "27") list("tnom" "27") list("digits" "12")) ?session sess)
        if(rexMatchp("noise" testName) then
          maeSetAnalysis(testName "pss" ?options list(list("errpreset" "conservative")) ?session sess)
        else
          maeSetAnalysis(testName "tran" ?options list(list("errpreset" "conservative") list("maxstep" maxstepValue) list("strobeperiod" "5p")) ?session sess)
        )
        fprintf(out "TEST %s MODE %L ERROR_OVERRIDE %L SIMULATOR %L TRAN %L PSS %L\n" testName asiGetHighPerformanceOptionVal(th 'uniMode) asiGetHighPerformanceOptionVal(th 'errorLevel) maeGetSimOption(testName ?session sess) maeGetAnalysis(testName "tran" ?session sess) maeGetAnalysis(testName "pss" ?session sess))
      )
    )
    maeEnableTests(?all t ?enable nil ?session sess)
    maeEnableTests(?testNames list("active_single_tone" "passive_single_tone") ?enable t ?session sess)
    maeSaveSetup(?session sess)
    fprintf(out "ENABLED %L\n" maeGetSetup(?enabled t ?session sess))
    close(out)
    printf("All native tests now use ordinary Spectre. Re-run only the two baselines from the GUI to verify emitted/effective accuracy.\n")
    when(fboundp('hw09FocusADEGUI) hw09FocusADEGUI())
    when(fboundp('hw09FocusADEGUI) hiRegTimer("hw09FocusADEGUI()" 5))
  )
)
hw09FixNativeAccuracy()
