; Native ADE Assembler configuration for editable schematic testbenches.
; Simulation is started only from the visible ADE Run All command.
procedure(hw09ConfigureADE()
  let((sess testHandle jp out windowNumber guiWindow)
    setShellEnvVar("CDS_LIC_FILE=5280@ece-winlic.ece.gatech.edu:1055@ansyslic.ecs.gatech.edu")
    setShellEnvVar("LM_LICENSE_FILE=5280@ece-winlic.ece.gatech.edu:1055@ansyslic.ecs.gatech.edu")
    envSetVal("spectre.outputs" "simOutputFormat" 'string "psf")
    envSetVal("spectre.turboOpts" "uniMode" 'string "Spectre")
    envSetVal("asimenv.startup" "projectDir" 'string "/nethome/sjeon84/Gatech-ECE6420/HW09/simulation/cadence_gui")
    envSetVal("adexl.results" "saveDir" 'string "/nethome/sjeon84/Gatech-ECE6420/HW09/simulation/cadence_gui")
    envSetVal("adexl.results" "saveResDir" 'string "/nethome/sjeon84/Gatech-ECE6420/HW09/simulation/cadence_gui")
    foreach(existing maeGetSessions()
      when(and(equal(axlGetSessionLibName(existing) "HW09_Mixers")
               equal(axlGetSessionCellName(existing) "mixer_campaign")) sess=existing)
    )
    unless(sess sess=maeOpenSetup("HW09_Mixers" "mixer_campaign" "maestro" ?application "Assembler"))
    unless(sess error("Cannot open native HW09 Assembler setup.\n"))
    maeSetCurrentRunMode(?runMode "Single Run, Sweeps and Corners" ?session sess)
    maeSetJobControlMode("ICRP" ?session sess)
    jp=maeGetJobPolicy(?session sess)
    jp->distributionmethod="Local"
    jp->maxjobs="2"
    jp->preemptivestart="0"
    jp->runtimeout="1800"
    maeSetJobPolicy(jp ?session sess)

    unless(member("active_single_tone" maeGetSetup(?session sess))
      maeCreateTest("active_single_tone" ?lib "HW09_Mixers" ?cell "active_tb" ?view "schematic" ?simulator "spectre" ?session sess))
    maeSetVar("pinDbm" "-55" ?typeName "test" ?typeValue list("active_single_tone") ?session sess)
    maeSetVar("fRF" "5800000000.0" ?typeName "test" ?typeValue list("active_single_tone") ?session sess)
    maeSetVar("fRF2" "5800000000.0" ?typeName "test" ?typeValue list("active_single_tone") ?session sess)
    maeSetVar("tone2Scale" "0" ?typeName "test" ?typeValue list("active_single_tone") ?session sess)
    maeSetVar("rfScale" "1" ?typeName "test" ?typeValue list("active_single_tone") ?session sess)
    maeSetEnvOption("active_single_tone" ?options list(list("modelFiles" list(list("/tools/designkits/NCSU/FreePDK4514/ncsu_basekit/models/hspice/tran_models/models_nom/NMOS_VTH.inc" "")))) ?session sess)
    maeSetSimOption("active_single_tone" ?options list(list("temp" "27") list("tnom" "27") list("reltol" "1e-05") list("vabstol" "1e-9") list("iabstol" "1e-13") list("gmin" "1e-12") list("digits" "12")) ?session sess)
    testHandle=maeGetTestSession("active_single_tone" ?session sess)
    asiSetHighPerformanceOptionVal(testHandle 'uniMode "Spectre")
    unless(equal(asiGetHighPerformanceOptionVal(testHandle 'uniMode) "Spectre") error("Cannot set ordinary Spectre engine.\n"))
    asiSetHighPerformanceOptionVal(testHandle 'errorLevel "Do not override")
    unless(maeSetAnalysis("active_single_tone" "tran" ?enable t ?options list(list("stop" "2.5e-08") list("maxstep" "2e-12") list("strobeperiod" "5e-12") list("errpreset" "conservative")) ?session sess) error("Could not configure active_single_tone/tran.\n"))
    maeAddOutput("rf" "active_single_tone" ?outputType "net" ?signalName "/rf" ?save t ?plot nil ?session sess)
    maeAddOutput("rfdrive" "active_single_tone" ?outputType "net" ?signalName "/rfdrive" ?save t ?plot nil ?session sess)
    maeAddOutput("outp" "active_single_tone" ?outputType "net" ?signalName "/outp" ?save t ?plot nil ?session sess)
    maeAddOutput("outn" "active_single_tone" ?outputType "net" ?signalName "/outn" ?save t ?plot nil ?session sess)
    maeAddOutput("lop" "active_single_tone" ?outputType "net" ?signalName "/lop" ?save t ?plot nil ?session sess)
    maeAddOutput("lon" "active_single_tone" ?outputType "net" ?signalName "/lon" ?save t ?plot nil ?session sess)
    maeAddOutput("tail" "active_single_tone" ?outputType "net" ?signalName "/tail" ?save t ?plot nil ?session sess)
    maeAddOutput("vdd_current" "active_single_tone" ?outputType "terminal" ?signalName "/VDD/PLUS" ?save t ?plot nil ?session sess)
    unless(member("active_single_window_check" maeGetSetup(?session sess))
      maeCreateTest("active_single_window_check" ?lib "HW09_Mixers" ?cell "active_tb" ?view "schematic" ?simulator "spectre" ?session sess))
    maeSetVar("pinDbm" "-55" ?typeName "test" ?typeValue list("active_single_window_check") ?session sess)
    maeSetVar("fRF" "5800000000.0" ?typeName "test" ?typeValue list("active_single_window_check") ?session sess)
    maeSetVar("fRF2" "5800000000.0" ?typeName "test" ?typeValue list("active_single_window_check") ?session sess)
    maeSetVar("tone2Scale" "0" ?typeName "test" ?typeValue list("active_single_window_check") ?session sess)
    maeSetVar("rfScale" "1" ?typeName "test" ?typeValue list("active_single_window_check") ?session sess)
    maeSetEnvOption("active_single_window_check" ?options list(list("modelFiles" list(list("/tools/designkits/NCSU/FreePDK4514/ncsu_basekit/models/hspice/tran_models/models_nom/NMOS_VTH.inc" "")))) ?session sess)
    maeSetSimOption("active_single_window_check" ?options list(list("temp" "27") list("tnom" "27") list("reltol" "1e-05") list("vabstol" "1e-9") list("iabstol" "1e-13") list("gmin" "1e-12") list("digits" "12")) ?session sess)
    testHandle=maeGetTestSession("active_single_window_check" ?session sess)
    asiSetHighPerformanceOptionVal(testHandle 'uniMode "Spectre")
    unless(equal(asiGetHighPerformanceOptionVal(testHandle 'uniMode) "Spectre") error("Cannot set ordinary Spectre engine.\n"))
    asiSetHighPerformanceOptionVal(testHandle 'errorLevel "Do not override")
    unless(maeSetAnalysis("active_single_window_check" "tran" ?enable t ?options list(list("stop" "1.2e-07") list("maxstep" "2e-12") list("strobeperiod" "5e-12") list("errpreset" "conservative")) ?session sess) error("Could not configure active_single_window_check/tran.\n"))
    maeAddOutput("rf" "active_single_window_check" ?outputType "net" ?signalName "/rf" ?save t ?plot nil ?session sess)
    maeAddOutput("rfdrive" "active_single_window_check" ?outputType "net" ?signalName "/rfdrive" ?save t ?plot nil ?session sess)
    maeAddOutput("outp" "active_single_window_check" ?outputType "net" ?signalName "/outp" ?save t ?plot nil ?session sess)
    maeAddOutput("outn" "active_single_window_check" ?outputType "net" ?signalName "/outn" ?save t ?plot nil ?session sess)
    maeAddOutput("lop" "active_single_window_check" ?outputType "net" ?signalName "/lop" ?save t ?plot nil ?session sess)
    maeAddOutput("lon" "active_single_window_check" ?outputType "net" ?signalName "/lon" ?save t ?plot nil ?session sess)
    maeAddOutput("tail" "active_single_window_check" ?outputType "net" ?signalName "/tail" ?save t ?plot nil ?session sess)
    maeAddOutput("vdd_current" "active_single_window_check" ?outputType "terminal" ?signalName "/VDD/PLUS" ?save t ?plot nil ?session sess)
    unless(member("active_compression_00" maeGetSetup(?session sess))
      maeCreateTest("active_compression_00" ?lib "HW09_Mixers" ?cell "active_tb" ?view "schematic" ?simulator "spectre" ?session sess))
    maeSetVar("pinDbm" "-60" ?typeName "test" ?typeValue list("active_compression_00") ?session sess)
    maeSetVar("fRF" "5800000000.0" ?typeName "test" ?typeValue list("active_compression_00") ?session sess)
    maeSetVar("fRF2" "5800000000.0" ?typeName "test" ?typeValue list("active_compression_00") ?session sess)
    maeSetVar("tone2Scale" "0" ?typeName "test" ?typeValue list("active_compression_00") ?session sess)
    maeSetVar("rfScale" "1" ?typeName "test" ?typeValue list("active_compression_00") ?session sess)
    maeSetEnvOption("active_compression_00" ?options list(list("modelFiles" list(list("/tools/designkits/NCSU/FreePDK4514/ncsu_basekit/models/hspice/tran_models/models_nom/NMOS_VTH.inc" "")))) ?session sess)
    maeSetSimOption("active_compression_00" ?options list(list("temp" "27") list("tnom" "27") list("reltol" "1e-05") list("vabstol" "1e-9") list("iabstol" "1e-13") list("gmin" "1e-12") list("digits" "12")) ?session sess)
    testHandle=maeGetTestSession("active_compression_00" ?session sess)
    asiSetHighPerformanceOptionVal(testHandle 'uniMode "Spectre")
    unless(equal(asiGetHighPerformanceOptionVal(testHandle 'uniMode) "Spectre") error("Cannot set ordinary Spectre engine.\n"))
    asiSetHighPerformanceOptionVal(testHandle 'errorLevel "Do not override")
    unless(maeSetAnalysis("active_compression_00" "tran" ?enable t ?options list(list("stop" "2.5e-08") list("maxstep" "2e-12") list("strobeperiod" "5e-12") list("errpreset" "conservative")) ?session sess) error("Could not configure active_compression_00/tran.\n"))
    maeAddOutput("rf" "active_compression_00" ?outputType "net" ?signalName "/rf" ?save t ?plot nil ?session sess)
    maeAddOutput("rfdrive" "active_compression_00" ?outputType "net" ?signalName "/rfdrive" ?save t ?plot nil ?session sess)
    maeAddOutput("outp" "active_compression_00" ?outputType "net" ?signalName "/outp" ?save t ?plot nil ?session sess)
    maeAddOutput("outn" "active_compression_00" ?outputType "net" ?signalName "/outn" ?save t ?plot nil ?session sess)
    maeAddOutput("lop" "active_compression_00" ?outputType "net" ?signalName "/lop" ?save t ?plot nil ?session sess)
    maeAddOutput("lon" "active_compression_00" ?outputType "net" ?signalName "/lon" ?save t ?plot nil ?session sess)
    maeAddOutput("tail" "active_compression_00" ?outputType "net" ?signalName "/tail" ?save t ?plot nil ?session sess)
    maeAddOutput("vdd_current" "active_compression_00" ?outputType "terminal" ?signalName "/VDD/PLUS" ?save t ?plot nil ?session sess)
    unless(member("active_compression_01" maeGetSetup(?session sess))
      maeCreateTest("active_compression_01" ?lib "HW09_Mixers" ?cell "active_tb" ?view "schematic" ?simulator "spectre" ?session sess))
    maeSetVar("pinDbm" "-50" ?typeName "test" ?typeValue list("active_compression_01") ?session sess)
    maeSetVar("fRF" "5800000000.0" ?typeName "test" ?typeValue list("active_compression_01") ?session sess)
    maeSetVar("fRF2" "5800000000.0" ?typeName "test" ?typeValue list("active_compression_01") ?session sess)
    maeSetVar("tone2Scale" "0" ?typeName "test" ?typeValue list("active_compression_01") ?session sess)
    maeSetVar("rfScale" "1" ?typeName "test" ?typeValue list("active_compression_01") ?session sess)
    maeSetEnvOption("active_compression_01" ?options list(list("modelFiles" list(list("/tools/designkits/NCSU/FreePDK4514/ncsu_basekit/models/hspice/tran_models/models_nom/NMOS_VTH.inc" "")))) ?session sess)
    maeSetSimOption("active_compression_01" ?options list(list("temp" "27") list("tnom" "27") list("reltol" "1e-05") list("vabstol" "1e-9") list("iabstol" "1e-13") list("gmin" "1e-12") list("digits" "12")) ?session sess)
    testHandle=maeGetTestSession("active_compression_01" ?session sess)
    asiSetHighPerformanceOptionVal(testHandle 'uniMode "Spectre")
    unless(equal(asiGetHighPerformanceOptionVal(testHandle 'uniMode) "Spectre") error("Cannot set ordinary Spectre engine.\n"))
    asiSetHighPerformanceOptionVal(testHandle 'errorLevel "Do not override")
    unless(maeSetAnalysis("active_compression_01" "tran" ?enable t ?options list(list("stop" "2.5e-08") list("maxstep" "2e-12") list("strobeperiod" "5e-12") list("errpreset" "conservative")) ?session sess) error("Could not configure active_compression_01/tran.\n"))
    maeAddOutput("rf" "active_compression_01" ?outputType "net" ?signalName "/rf" ?save t ?plot nil ?session sess)
    maeAddOutput("rfdrive" "active_compression_01" ?outputType "net" ?signalName "/rfdrive" ?save t ?plot nil ?session sess)
    maeAddOutput("outp" "active_compression_01" ?outputType "net" ?signalName "/outp" ?save t ?plot nil ?session sess)
    maeAddOutput("outn" "active_compression_01" ?outputType "net" ?signalName "/outn" ?save t ?plot nil ?session sess)
    maeAddOutput("lop" "active_compression_01" ?outputType "net" ?signalName "/lop" ?save t ?plot nil ?session sess)
    maeAddOutput("lon" "active_compression_01" ?outputType "net" ?signalName "/lon" ?save t ?plot nil ?session sess)
    maeAddOutput("tail" "active_compression_01" ?outputType "net" ?signalName "/tail" ?save t ?plot nil ?session sess)
    maeAddOutput("vdd_current" "active_compression_01" ?outputType "terminal" ?signalName "/VDD/PLUS" ?save t ?plot nil ?session sess)
    unless(member("active_compression_02" maeGetSetup(?session sess))
      maeCreateTest("active_compression_02" ?lib "HW09_Mixers" ?cell "active_tb" ?view "schematic" ?simulator "spectre" ?session sess))
    maeSetVar("pinDbm" "-40" ?typeName "test" ?typeValue list("active_compression_02") ?session sess)
    maeSetVar("fRF" "5800000000.0" ?typeName "test" ?typeValue list("active_compression_02") ?session sess)
    maeSetVar("fRF2" "5800000000.0" ?typeName "test" ?typeValue list("active_compression_02") ?session sess)
    maeSetVar("tone2Scale" "0" ?typeName "test" ?typeValue list("active_compression_02") ?session sess)
    maeSetVar("rfScale" "1" ?typeName "test" ?typeValue list("active_compression_02") ?session sess)
    maeSetEnvOption("active_compression_02" ?options list(list("modelFiles" list(list("/tools/designkits/NCSU/FreePDK4514/ncsu_basekit/models/hspice/tran_models/models_nom/NMOS_VTH.inc" "")))) ?session sess)
    maeSetSimOption("active_compression_02" ?options list(list("temp" "27") list("tnom" "27") list("reltol" "1e-05") list("vabstol" "1e-9") list("iabstol" "1e-13") list("gmin" "1e-12") list("digits" "12")) ?session sess)
    testHandle=maeGetTestSession("active_compression_02" ?session sess)
    asiSetHighPerformanceOptionVal(testHandle 'uniMode "Spectre")
    unless(equal(asiGetHighPerformanceOptionVal(testHandle 'uniMode) "Spectre") error("Cannot set ordinary Spectre engine.\n"))
    asiSetHighPerformanceOptionVal(testHandle 'errorLevel "Do not override")
    unless(maeSetAnalysis("active_compression_02" "tran" ?enable t ?options list(list("stop" "2.5e-08") list("maxstep" "2e-12") list("strobeperiod" "5e-12") list("errpreset" "conservative")) ?session sess) error("Could not configure active_compression_02/tran.\n"))
    maeAddOutput("rf" "active_compression_02" ?outputType "net" ?signalName "/rf" ?save t ?plot nil ?session sess)
    maeAddOutput("rfdrive" "active_compression_02" ?outputType "net" ?signalName "/rfdrive" ?save t ?plot nil ?session sess)
    maeAddOutput("outp" "active_compression_02" ?outputType "net" ?signalName "/outp" ?save t ?plot nil ?session sess)
    maeAddOutput("outn" "active_compression_02" ?outputType "net" ?signalName "/outn" ?save t ?plot nil ?session sess)
    maeAddOutput("lop" "active_compression_02" ?outputType "net" ?signalName "/lop" ?save t ?plot nil ?session sess)
    maeAddOutput("lon" "active_compression_02" ?outputType "net" ?signalName "/lon" ?save t ?plot nil ?session sess)
    maeAddOutput("tail" "active_compression_02" ?outputType "net" ?signalName "/tail" ?save t ?plot nil ?session sess)
    maeAddOutput("vdd_current" "active_compression_02" ?outputType "terminal" ?signalName "/VDD/PLUS" ?save t ?plot nil ?session sess)
    unless(member("active_compression_03" maeGetSetup(?session sess))
      maeCreateTest("active_compression_03" ?lib "HW09_Mixers" ?cell "active_tb" ?view "schematic" ?simulator "spectre" ?session sess))
    maeSetVar("pinDbm" "-35" ?typeName "test" ?typeValue list("active_compression_03") ?session sess)
    maeSetVar("fRF" "5800000000.0" ?typeName "test" ?typeValue list("active_compression_03") ?session sess)
    maeSetVar("fRF2" "5800000000.0" ?typeName "test" ?typeValue list("active_compression_03") ?session sess)
    maeSetVar("tone2Scale" "0" ?typeName "test" ?typeValue list("active_compression_03") ?session sess)
    maeSetVar("rfScale" "1" ?typeName "test" ?typeValue list("active_compression_03") ?session sess)
    maeSetEnvOption("active_compression_03" ?options list(list("modelFiles" list(list("/tools/designkits/NCSU/FreePDK4514/ncsu_basekit/models/hspice/tran_models/models_nom/NMOS_VTH.inc" "")))) ?session sess)
    maeSetSimOption("active_compression_03" ?options list(list("temp" "27") list("tnom" "27") list("reltol" "1e-05") list("vabstol" "1e-9") list("iabstol" "1e-13") list("gmin" "1e-12") list("digits" "12")) ?session sess)
    testHandle=maeGetTestSession("active_compression_03" ?session sess)
    asiSetHighPerformanceOptionVal(testHandle 'uniMode "Spectre")
    unless(equal(asiGetHighPerformanceOptionVal(testHandle 'uniMode) "Spectre") error("Cannot set ordinary Spectre engine.\n"))
    asiSetHighPerformanceOptionVal(testHandle 'errorLevel "Do not override")
    unless(maeSetAnalysis("active_compression_03" "tran" ?enable t ?options list(list("stop" "2.5e-08") list("maxstep" "2e-12") list("strobeperiod" "5e-12") list("errpreset" "conservative")) ?session sess) error("Could not configure active_compression_03/tran.\n"))
    maeAddOutput("rf" "active_compression_03" ?outputType "net" ?signalName "/rf" ?save t ?plot nil ?session sess)
    maeAddOutput("rfdrive" "active_compression_03" ?outputType "net" ?signalName "/rfdrive" ?save t ?plot nil ?session sess)
    maeAddOutput("outp" "active_compression_03" ?outputType "net" ?signalName "/outp" ?save t ?plot nil ?session sess)
    maeAddOutput("outn" "active_compression_03" ?outputType "net" ?signalName "/outn" ?save t ?plot nil ?session sess)
    maeAddOutput("lop" "active_compression_03" ?outputType "net" ?signalName "/lop" ?save t ?plot nil ?session sess)
    maeAddOutput("lon" "active_compression_03" ?outputType "net" ?signalName "/lon" ?save t ?plot nil ?session sess)
    maeAddOutput("tail" "active_compression_03" ?outputType "net" ?signalName "/tail" ?save t ?plot nil ?session sess)
    maeAddOutput("vdd_current" "active_compression_03" ?outputType "terminal" ?signalName "/VDD/PLUS" ?save t ?plot nil ?session sess)
    unless(member("active_compression_04" maeGetSetup(?session sess))
      maeCreateTest("active_compression_04" ?lib "HW09_Mixers" ?cell "active_tb" ?view "schematic" ?simulator "spectre" ?session sess))
    maeSetVar("pinDbm" "-30" ?typeName "test" ?typeValue list("active_compression_04") ?session sess)
    maeSetVar("fRF" "5800000000.0" ?typeName "test" ?typeValue list("active_compression_04") ?session sess)
    maeSetVar("fRF2" "5800000000.0" ?typeName "test" ?typeValue list("active_compression_04") ?session sess)
    maeSetVar("tone2Scale" "0" ?typeName "test" ?typeValue list("active_compression_04") ?session sess)
    maeSetVar("rfScale" "1" ?typeName "test" ?typeValue list("active_compression_04") ?session sess)
    maeSetEnvOption("active_compression_04" ?options list(list("modelFiles" list(list("/tools/designkits/NCSU/FreePDK4514/ncsu_basekit/models/hspice/tran_models/models_nom/NMOS_VTH.inc" "")))) ?session sess)
    maeSetSimOption("active_compression_04" ?options list(list("temp" "27") list("tnom" "27") list("reltol" "1e-05") list("vabstol" "1e-9") list("iabstol" "1e-13") list("gmin" "1e-12") list("digits" "12")) ?session sess)
    testHandle=maeGetTestSession("active_compression_04" ?session sess)
    asiSetHighPerformanceOptionVal(testHandle 'uniMode "Spectre")
    unless(equal(asiGetHighPerformanceOptionVal(testHandle 'uniMode) "Spectre") error("Cannot set ordinary Spectre engine.\n"))
    asiSetHighPerformanceOptionVal(testHandle 'errorLevel "Do not override")
    unless(maeSetAnalysis("active_compression_04" "tran" ?enable t ?options list(list("stop" "2.5e-08") list("maxstep" "2e-12") list("strobeperiod" "5e-12") list("errpreset" "conservative")) ?session sess) error("Could not configure active_compression_04/tran.\n"))
    maeAddOutput("rf" "active_compression_04" ?outputType "net" ?signalName "/rf" ?save t ?plot nil ?session sess)
    maeAddOutput("rfdrive" "active_compression_04" ?outputType "net" ?signalName "/rfdrive" ?save t ?plot nil ?session sess)
    maeAddOutput("outp" "active_compression_04" ?outputType "net" ?signalName "/outp" ?save t ?plot nil ?session sess)
    maeAddOutput("outn" "active_compression_04" ?outputType "net" ?signalName "/outn" ?save t ?plot nil ?session sess)
    maeAddOutput("lop" "active_compression_04" ?outputType "net" ?signalName "/lop" ?save t ?plot nil ?session sess)
    maeAddOutput("lon" "active_compression_04" ?outputType "net" ?signalName "/lon" ?save t ?plot nil ?session sess)
    maeAddOutput("tail" "active_compression_04" ?outputType "net" ?signalName "/tail" ?save t ?plot nil ?session sess)
    maeAddOutput("vdd_current" "active_compression_04" ?outputType "terminal" ?signalName "/VDD/PLUS" ?save t ?plot nil ?session sess)
    unless(member("active_compression_05" maeGetSetup(?session sess))
      maeCreateTest("active_compression_05" ?lib "HW09_Mixers" ?cell "active_tb" ?view "schematic" ?simulator "spectre" ?session sess))
    maeSetVar("pinDbm" "-25" ?typeName "test" ?typeValue list("active_compression_05") ?session sess)
    maeSetVar("fRF" "5800000000.0" ?typeName "test" ?typeValue list("active_compression_05") ?session sess)
    maeSetVar("fRF2" "5800000000.0" ?typeName "test" ?typeValue list("active_compression_05") ?session sess)
    maeSetVar("tone2Scale" "0" ?typeName "test" ?typeValue list("active_compression_05") ?session sess)
    maeSetVar("rfScale" "1" ?typeName "test" ?typeValue list("active_compression_05") ?session sess)
    maeSetEnvOption("active_compression_05" ?options list(list("modelFiles" list(list("/tools/designkits/NCSU/FreePDK4514/ncsu_basekit/models/hspice/tran_models/models_nom/NMOS_VTH.inc" "")))) ?session sess)
    maeSetSimOption("active_compression_05" ?options list(list("temp" "27") list("tnom" "27") list("reltol" "1e-05") list("vabstol" "1e-9") list("iabstol" "1e-13") list("gmin" "1e-12") list("digits" "12")) ?session sess)
    testHandle=maeGetTestSession("active_compression_05" ?session sess)
    asiSetHighPerformanceOptionVal(testHandle 'uniMode "Spectre")
    unless(equal(asiGetHighPerformanceOptionVal(testHandle 'uniMode) "Spectre") error("Cannot set ordinary Spectre engine.\n"))
    asiSetHighPerformanceOptionVal(testHandle 'errorLevel "Do not override")
    unless(maeSetAnalysis("active_compression_05" "tran" ?enable t ?options list(list("stop" "2.5e-08") list("maxstep" "2e-12") list("strobeperiod" "5e-12") list("errpreset" "conservative")) ?session sess) error("Could not configure active_compression_05/tran.\n"))
    maeAddOutput("rf" "active_compression_05" ?outputType "net" ?signalName "/rf" ?save t ?plot nil ?session sess)
    maeAddOutput("rfdrive" "active_compression_05" ?outputType "net" ?signalName "/rfdrive" ?save t ?plot nil ?session sess)
    maeAddOutput("outp" "active_compression_05" ?outputType "net" ?signalName "/outp" ?save t ?plot nil ?session sess)
    maeAddOutput("outn" "active_compression_05" ?outputType "net" ?signalName "/outn" ?save t ?plot nil ?session sess)
    maeAddOutput("lop" "active_compression_05" ?outputType "net" ?signalName "/lop" ?save t ?plot nil ?session sess)
    maeAddOutput("lon" "active_compression_05" ?outputType "net" ?signalName "/lon" ?save t ?plot nil ?session sess)
    maeAddOutput("tail" "active_compression_05" ?outputType "net" ?signalName "/tail" ?save t ?plot nil ?session sess)
    maeAddOutput("vdd_current" "active_compression_05" ?outputType "terminal" ?signalName "/VDD/PLUS" ?save t ?plot nil ?session sess)
    unless(member("active_compression_06" maeGetSetup(?session sess))
      maeCreateTest("active_compression_06" ?lib "HW09_Mixers" ?cell "active_tb" ?view "schematic" ?simulator "spectre" ?session sess))
    maeSetVar("pinDbm" "-20" ?typeName "test" ?typeValue list("active_compression_06") ?session sess)
    maeSetVar("fRF" "5800000000.0" ?typeName "test" ?typeValue list("active_compression_06") ?session sess)
    maeSetVar("fRF2" "5800000000.0" ?typeName "test" ?typeValue list("active_compression_06") ?session sess)
    maeSetVar("tone2Scale" "0" ?typeName "test" ?typeValue list("active_compression_06") ?session sess)
    maeSetVar("rfScale" "1" ?typeName "test" ?typeValue list("active_compression_06") ?session sess)
    maeSetEnvOption("active_compression_06" ?options list(list("modelFiles" list(list("/tools/designkits/NCSU/FreePDK4514/ncsu_basekit/models/hspice/tran_models/models_nom/NMOS_VTH.inc" "")))) ?session sess)
    maeSetSimOption("active_compression_06" ?options list(list("temp" "27") list("tnom" "27") list("reltol" "1e-05") list("vabstol" "1e-9") list("iabstol" "1e-13") list("gmin" "1e-12") list("digits" "12")) ?session sess)
    testHandle=maeGetTestSession("active_compression_06" ?session sess)
    asiSetHighPerformanceOptionVal(testHandle 'uniMode "Spectre")
    unless(equal(asiGetHighPerformanceOptionVal(testHandle 'uniMode) "Spectre") error("Cannot set ordinary Spectre engine.\n"))
    asiSetHighPerformanceOptionVal(testHandle 'errorLevel "Do not override")
    unless(maeSetAnalysis("active_compression_06" "tran" ?enable t ?options list(list("stop" "2.5e-08") list("maxstep" "2e-12") list("strobeperiod" "5e-12") list("errpreset" "conservative")) ?session sess) error("Could not configure active_compression_06/tran.\n"))
    maeAddOutput("rf" "active_compression_06" ?outputType "net" ?signalName "/rf" ?save t ?plot nil ?session sess)
    maeAddOutput("rfdrive" "active_compression_06" ?outputType "net" ?signalName "/rfdrive" ?save t ?plot nil ?session sess)
    maeAddOutput("outp" "active_compression_06" ?outputType "net" ?signalName "/outp" ?save t ?plot nil ?session sess)
    maeAddOutput("outn" "active_compression_06" ?outputType "net" ?signalName "/outn" ?save t ?plot nil ?session sess)
    maeAddOutput("lop" "active_compression_06" ?outputType "net" ?signalName "/lop" ?save t ?plot nil ?session sess)
    maeAddOutput("lon" "active_compression_06" ?outputType "net" ?signalName "/lon" ?save t ?plot nil ?session sess)
    maeAddOutput("tail" "active_compression_06" ?outputType "net" ?signalName "/tail" ?save t ?plot nil ?session sess)
    maeAddOutput("vdd_current" "active_compression_06" ?outputType "terminal" ?signalName "/VDD/PLUS" ?save t ?plot nil ?session sess)
    unless(member("active_compression_07" maeGetSetup(?session sess))
      maeCreateTest("active_compression_07" ?lib "HW09_Mixers" ?cell "active_tb" ?view "schematic" ?simulator "spectre" ?session sess))
    maeSetVar("pinDbm" "-17.5" ?typeName "test" ?typeValue list("active_compression_07") ?session sess)
    maeSetVar("fRF" "5800000000.0" ?typeName "test" ?typeValue list("active_compression_07") ?session sess)
    maeSetVar("fRF2" "5800000000.0" ?typeName "test" ?typeValue list("active_compression_07") ?session sess)
    maeSetVar("tone2Scale" "0" ?typeName "test" ?typeValue list("active_compression_07") ?session sess)
    maeSetVar("rfScale" "1" ?typeName "test" ?typeValue list("active_compression_07") ?session sess)
    maeSetEnvOption("active_compression_07" ?options list(list("modelFiles" list(list("/tools/designkits/NCSU/FreePDK4514/ncsu_basekit/models/hspice/tran_models/models_nom/NMOS_VTH.inc" "")))) ?session sess)
    maeSetSimOption("active_compression_07" ?options list(list("temp" "27") list("tnom" "27") list("reltol" "1e-05") list("vabstol" "1e-9") list("iabstol" "1e-13") list("gmin" "1e-12") list("digits" "12")) ?session sess)
    testHandle=maeGetTestSession("active_compression_07" ?session sess)
    asiSetHighPerformanceOptionVal(testHandle 'uniMode "Spectre")
    unless(equal(asiGetHighPerformanceOptionVal(testHandle 'uniMode) "Spectre") error("Cannot set ordinary Spectre engine.\n"))
    asiSetHighPerformanceOptionVal(testHandle 'errorLevel "Do not override")
    unless(maeSetAnalysis("active_compression_07" "tran" ?enable t ?options list(list("stop" "2.5e-08") list("maxstep" "2e-12") list("strobeperiod" "5e-12") list("errpreset" "conservative")) ?session sess) error("Could not configure active_compression_07/tran.\n"))
    maeAddOutput("rf" "active_compression_07" ?outputType "net" ?signalName "/rf" ?save t ?plot nil ?session sess)
    maeAddOutput("rfdrive" "active_compression_07" ?outputType "net" ?signalName "/rfdrive" ?save t ?plot nil ?session sess)
    maeAddOutput("outp" "active_compression_07" ?outputType "net" ?signalName "/outp" ?save t ?plot nil ?session sess)
    maeAddOutput("outn" "active_compression_07" ?outputType "net" ?signalName "/outn" ?save t ?plot nil ?session sess)
    maeAddOutput("lop" "active_compression_07" ?outputType "net" ?signalName "/lop" ?save t ?plot nil ?session sess)
    maeAddOutput("lon" "active_compression_07" ?outputType "net" ?signalName "/lon" ?save t ?plot nil ?session sess)
    maeAddOutput("tail" "active_compression_07" ?outputType "net" ?signalName "/tail" ?save t ?plot nil ?session sess)
    maeAddOutput("vdd_current" "active_compression_07" ?outputType "terminal" ?signalName "/VDD/PLUS" ?save t ?plot nil ?session sess)
    unless(member("active_compression_08" maeGetSetup(?session sess))
      maeCreateTest("active_compression_08" ?lib "HW09_Mixers" ?cell "active_tb" ?view "schematic" ?simulator "spectre" ?session sess))
    maeSetVar("pinDbm" "-16.25" ?typeName "test" ?typeValue list("active_compression_08") ?session sess)
    maeSetVar("fRF" "5800000000.0" ?typeName "test" ?typeValue list("active_compression_08") ?session sess)
    maeSetVar("fRF2" "5800000000.0" ?typeName "test" ?typeValue list("active_compression_08") ?session sess)
    maeSetVar("tone2Scale" "0" ?typeName "test" ?typeValue list("active_compression_08") ?session sess)
    maeSetVar("rfScale" "1" ?typeName "test" ?typeValue list("active_compression_08") ?session sess)
    maeSetEnvOption("active_compression_08" ?options list(list("modelFiles" list(list("/tools/designkits/NCSU/FreePDK4514/ncsu_basekit/models/hspice/tran_models/models_nom/NMOS_VTH.inc" "")))) ?session sess)
    maeSetSimOption("active_compression_08" ?options list(list("temp" "27") list("tnom" "27") list("reltol" "1e-05") list("vabstol" "1e-9") list("iabstol" "1e-13") list("gmin" "1e-12") list("digits" "12")) ?session sess)
    testHandle=maeGetTestSession("active_compression_08" ?session sess)
    asiSetHighPerformanceOptionVal(testHandle 'uniMode "Spectre")
    unless(equal(asiGetHighPerformanceOptionVal(testHandle 'uniMode) "Spectre") error("Cannot set ordinary Spectre engine.\n"))
    asiSetHighPerformanceOptionVal(testHandle 'errorLevel "Do not override")
    unless(maeSetAnalysis("active_compression_08" "tran" ?enable t ?options list(list("stop" "2.5e-08") list("maxstep" "2e-12") list("strobeperiod" "5e-12") list("errpreset" "conservative")) ?session sess) error("Could not configure active_compression_08/tran.\n"))
    maeAddOutput("rf" "active_compression_08" ?outputType "net" ?signalName "/rf" ?save t ?plot nil ?session sess)
    maeAddOutput("rfdrive" "active_compression_08" ?outputType "net" ?signalName "/rfdrive" ?save t ?plot nil ?session sess)
    maeAddOutput("outp" "active_compression_08" ?outputType "net" ?signalName "/outp" ?save t ?plot nil ?session sess)
    maeAddOutput("outn" "active_compression_08" ?outputType "net" ?signalName "/outn" ?save t ?plot nil ?session sess)
    maeAddOutput("lop" "active_compression_08" ?outputType "net" ?signalName "/lop" ?save t ?plot nil ?session sess)
    maeAddOutput("lon" "active_compression_08" ?outputType "net" ?signalName "/lon" ?save t ?plot nil ?session sess)
    maeAddOutput("tail" "active_compression_08" ?outputType "net" ?signalName "/tail" ?save t ?plot nil ?session sess)
    maeAddOutput("vdd_current" "active_compression_08" ?outputType "terminal" ?signalName "/VDD/PLUS" ?save t ?plot nil ?session sess)
    unless(member("active_compression_09" maeGetSetup(?session sess))
      maeCreateTest("active_compression_09" ?lib "HW09_Mixers" ?cell "active_tb" ?view "schematic" ?simulator "spectre" ?session sess))
    maeSetVar("pinDbm" "-15.625" ?typeName "test" ?typeValue list("active_compression_09") ?session sess)
    maeSetVar("fRF" "5800000000.0" ?typeName "test" ?typeValue list("active_compression_09") ?session sess)
    maeSetVar("fRF2" "5800000000.0" ?typeName "test" ?typeValue list("active_compression_09") ?session sess)
    maeSetVar("tone2Scale" "0" ?typeName "test" ?typeValue list("active_compression_09") ?session sess)
    maeSetVar("rfScale" "1" ?typeName "test" ?typeValue list("active_compression_09") ?session sess)
    maeSetEnvOption("active_compression_09" ?options list(list("modelFiles" list(list("/tools/designkits/NCSU/FreePDK4514/ncsu_basekit/models/hspice/tran_models/models_nom/NMOS_VTH.inc" "")))) ?session sess)
    maeSetSimOption("active_compression_09" ?options list(list("temp" "27") list("tnom" "27") list("reltol" "1e-05") list("vabstol" "1e-9") list("iabstol" "1e-13") list("gmin" "1e-12") list("digits" "12")) ?session sess)
    testHandle=maeGetTestSession("active_compression_09" ?session sess)
    asiSetHighPerformanceOptionVal(testHandle 'uniMode "Spectre")
    unless(equal(asiGetHighPerformanceOptionVal(testHandle 'uniMode) "Spectre") error("Cannot set ordinary Spectre engine.\n"))
    asiSetHighPerformanceOptionVal(testHandle 'errorLevel "Do not override")
    unless(maeSetAnalysis("active_compression_09" "tran" ?enable t ?options list(list("stop" "2.5e-08") list("maxstep" "2e-12") list("strobeperiod" "5e-12") list("errpreset" "conservative")) ?session sess) error("Could not configure active_compression_09/tran.\n"))
    maeAddOutput("rf" "active_compression_09" ?outputType "net" ?signalName "/rf" ?save t ?plot nil ?session sess)
    maeAddOutput("rfdrive" "active_compression_09" ?outputType "net" ?signalName "/rfdrive" ?save t ?plot nil ?session sess)
    maeAddOutput("outp" "active_compression_09" ?outputType "net" ?signalName "/outp" ?save t ?plot nil ?session sess)
    maeAddOutput("outn" "active_compression_09" ?outputType "net" ?signalName "/outn" ?save t ?plot nil ?session sess)
    maeAddOutput("lop" "active_compression_09" ?outputType "net" ?signalName "/lop" ?save t ?plot nil ?session sess)
    maeAddOutput("lon" "active_compression_09" ?outputType "net" ?signalName "/lon" ?save t ?plot nil ?session sess)
    maeAddOutput("tail" "active_compression_09" ?outputType "net" ?signalName "/tail" ?save t ?plot nil ?session sess)
    maeAddOutput("vdd_current" "active_compression_09" ?outputType "terminal" ?signalName "/VDD/PLUS" ?save t ?plot nil ?session sess)
    unless(member("active_compression_10" maeGetSetup(?session sess))
      maeCreateTest("active_compression_10" ?lib "HW09_Mixers" ?cell "active_tb" ?view "schematic" ?simulator "spectre" ?session sess))
    maeSetVar("pinDbm" "-15.46875" ?typeName "test" ?typeValue list("active_compression_10") ?session sess)
    maeSetVar("fRF" "5800000000.0" ?typeName "test" ?typeValue list("active_compression_10") ?session sess)
    maeSetVar("fRF2" "5800000000.0" ?typeName "test" ?typeValue list("active_compression_10") ?session sess)
    maeSetVar("tone2Scale" "0" ?typeName "test" ?typeValue list("active_compression_10") ?session sess)
    maeSetVar("rfScale" "1" ?typeName "test" ?typeValue list("active_compression_10") ?session sess)
    maeSetEnvOption("active_compression_10" ?options list(list("modelFiles" list(list("/tools/designkits/NCSU/FreePDK4514/ncsu_basekit/models/hspice/tran_models/models_nom/NMOS_VTH.inc" "")))) ?session sess)
    maeSetSimOption("active_compression_10" ?options list(list("temp" "27") list("tnom" "27") list("reltol" "1e-05") list("vabstol" "1e-9") list("iabstol" "1e-13") list("gmin" "1e-12") list("digits" "12")) ?session sess)
    testHandle=maeGetTestSession("active_compression_10" ?session sess)
    asiSetHighPerformanceOptionVal(testHandle 'uniMode "Spectre")
    unless(equal(asiGetHighPerformanceOptionVal(testHandle 'uniMode) "Spectre") error("Cannot set ordinary Spectre engine.\n"))
    asiSetHighPerformanceOptionVal(testHandle 'errorLevel "Do not override")
    unless(maeSetAnalysis("active_compression_10" "tran" ?enable t ?options list(list("stop" "2.5e-08") list("maxstep" "2e-12") list("strobeperiod" "5e-12") list("errpreset" "conservative")) ?session sess) error("Could not configure active_compression_10/tran.\n"))
    maeAddOutput("rf" "active_compression_10" ?outputType "net" ?signalName "/rf" ?save t ?plot nil ?session sess)
    maeAddOutput("rfdrive" "active_compression_10" ?outputType "net" ?signalName "/rfdrive" ?save t ?plot nil ?session sess)
    maeAddOutput("outp" "active_compression_10" ?outputType "net" ?signalName "/outp" ?save t ?plot nil ?session sess)
    maeAddOutput("outn" "active_compression_10" ?outputType "net" ?signalName "/outn" ?save t ?plot nil ?session sess)
    maeAddOutput("lop" "active_compression_10" ?outputType "net" ?signalName "/lop" ?save t ?plot nil ?session sess)
    maeAddOutput("lon" "active_compression_10" ?outputType "net" ?signalName "/lon" ?save t ?plot nil ?session sess)
    maeAddOutput("tail" "active_compression_10" ?outputType "net" ?signalName "/tail" ?save t ?plot nil ?session sess)
    maeAddOutput("vdd_current" "active_compression_10" ?outputType "terminal" ?signalName "/VDD/PLUS" ?save t ?plot nil ?session sess)
    unless(member("active_compression_11" maeGetSetup(?session sess))
      maeCreateTest("active_compression_11" ?lib "HW09_Mixers" ?cell "active_tb" ?view "schematic" ?simulator "spectre" ?session sess))
    maeSetVar("pinDbm" "-15.15625" ?typeName "test" ?typeValue list("active_compression_11") ?session sess)
    maeSetVar("fRF" "5800000000.0" ?typeName "test" ?typeValue list("active_compression_11") ?session sess)
    maeSetVar("fRF2" "5800000000.0" ?typeName "test" ?typeValue list("active_compression_11") ?session sess)
    maeSetVar("tone2Scale" "0" ?typeName "test" ?typeValue list("active_compression_11") ?session sess)
    maeSetVar("rfScale" "1" ?typeName "test" ?typeValue list("active_compression_11") ?session sess)
    maeSetEnvOption("active_compression_11" ?options list(list("modelFiles" list(list("/tools/designkits/NCSU/FreePDK4514/ncsu_basekit/models/hspice/tran_models/models_nom/NMOS_VTH.inc" "")))) ?session sess)
    maeSetSimOption("active_compression_11" ?options list(list("temp" "27") list("tnom" "27") list("reltol" "1e-05") list("vabstol" "1e-9") list("iabstol" "1e-13") list("gmin" "1e-12") list("digits" "12")) ?session sess)
    testHandle=maeGetTestSession("active_compression_11" ?session sess)
    asiSetHighPerformanceOptionVal(testHandle 'uniMode "Spectre")
    unless(equal(asiGetHighPerformanceOptionVal(testHandle 'uniMode) "Spectre") error("Cannot set ordinary Spectre engine.\n"))
    asiSetHighPerformanceOptionVal(testHandle 'errorLevel "Do not override")
    unless(maeSetAnalysis("active_compression_11" "tran" ?enable t ?options list(list("stop" "2.5e-08") list("maxstep" "2e-12") list("strobeperiod" "5e-12") list("errpreset" "conservative")) ?session sess) error("Could not configure active_compression_11/tran.\n"))
    maeAddOutput("rf" "active_compression_11" ?outputType "net" ?signalName "/rf" ?save t ?plot nil ?session sess)
    maeAddOutput("rfdrive" "active_compression_11" ?outputType "net" ?signalName "/rfdrive" ?save t ?plot nil ?session sess)
    maeAddOutput("outp" "active_compression_11" ?outputType "net" ?signalName "/outp" ?save t ?plot nil ?session sess)
    maeAddOutput("outn" "active_compression_11" ?outputType "net" ?signalName "/outn" ?save t ?plot nil ?session sess)
    maeAddOutput("lop" "active_compression_11" ?outputType "net" ?signalName "/lop" ?save t ?plot nil ?session sess)
    maeAddOutput("lon" "active_compression_11" ?outputType "net" ?signalName "/lon" ?save t ?plot nil ?session sess)
    maeAddOutput("tail" "active_compression_11" ?outputType "net" ?signalName "/tail" ?save t ?plot nil ?session sess)
    maeAddOutput("vdd_current" "active_compression_11" ?outputType "terminal" ?signalName "/VDD/PLUS" ?save t ?plot nil ?session sess)
    unless(member("active_compression_12" maeGetSetup(?session sess))
      maeCreateTest("active_compression_12" ?lib "HW09_Mixers" ?cell "active_tb" ?view "schematic" ?simulator "spectre" ?session sess))
    maeSetVar("pinDbm" "-15" ?typeName "test" ?typeValue list("active_compression_12") ?session sess)
    maeSetVar("fRF" "5800000000.0" ?typeName "test" ?typeValue list("active_compression_12") ?session sess)
    maeSetVar("fRF2" "5800000000.0" ?typeName "test" ?typeValue list("active_compression_12") ?session sess)
    maeSetVar("tone2Scale" "0" ?typeName "test" ?typeValue list("active_compression_12") ?session sess)
    maeSetVar("rfScale" "1" ?typeName "test" ?typeValue list("active_compression_12") ?session sess)
    maeSetEnvOption("active_compression_12" ?options list(list("modelFiles" list(list("/tools/designkits/NCSU/FreePDK4514/ncsu_basekit/models/hspice/tran_models/models_nom/NMOS_VTH.inc" "")))) ?session sess)
    maeSetSimOption("active_compression_12" ?options list(list("temp" "27") list("tnom" "27") list("reltol" "1e-05") list("vabstol" "1e-9") list("iabstol" "1e-13") list("gmin" "1e-12") list("digits" "12")) ?session sess)
    testHandle=maeGetTestSession("active_compression_12" ?session sess)
    asiSetHighPerformanceOptionVal(testHandle 'uniMode "Spectre")
    unless(equal(asiGetHighPerformanceOptionVal(testHandle 'uniMode) "Spectre") error("Cannot set ordinary Spectre engine.\n"))
    asiSetHighPerformanceOptionVal(testHandle 'errorLevel "Do not override")
    unless(maeSetAnalysis("active_compression_12" "tran" ?enable t ?options list(list("stop" "2.5e-08") list("maxstep" "2e-12") list("strobeperiod" "5e-12") list("errpreset" "conservative")) ?session sess) error("Could not configure active_compression_12/tran.\n"))
    maeAddOutput("rf" "active_compression_12" ?outputType "net" ?signalName "/rf" ?save t ?plot nil ?session sess)
    maeAddOutput("rfdrive" "active_compression_12" ?outputType "net" ?signalName "/rfdrive" ?save t ?plot nil ?session sess)
    maeAddOutput("outp" "active_compression_12" ?outputType "net" ?signalName "/outp" ?save t ?plot nil ?session sess)
    maeAddOutput("outn" "active_compression_12" ?outputType "net" ?signalName "/outn" ?save t ?plot nil ?session sess)
    maeAddOutput("lop" "active_compression_12" ?outputType "net" ?signalName "/lop" ?save t ?plot nil ?session sess)
    maeAddOutput("lon" "active_compression_12" ?outputType "net" ?signalName "/lon" ?save t ?plot nil ?session sess)
    maeAddOutput("tail" "active_compression_12" ?outputType "net" ?signalName "/tail" ?save t ?plot nil ?session sess)
    maeAddOutput("vdd_current" "active_compression_12" ?outputType "terminal" ?signalName "/VDD/PLUS" ?save t ?plot nil ?session sess)
    unless(member("active_compression_13" maeGetSetup(?session sess))
      maeCreateTest("active_compression_13" ?lib "HW09_Mixers" ?cell "active_tb" ?view "schematic" ?simulator "spectre" ?session sess))
    maeSetVar("pinDbm" "-10" ?typeName "test" ?typeValue list("active_compression_13") ?session sess)
    maeSetVar("fRF" "5800000000.0" ?typeName "test" ?typeValue list("active_compression_13") ?session sess)
    maeSetVar("fRF2" "5800000000.0" ?typeName "test" ?typeValue list("active_compression_13") ?session sess)
    maeSetVar("tone2Scale" "0" ?typeName "test" ?typeValue list("active_compression_13") ?session sess)
    maeSetVar("rfScale" "1" ?typeName "test" ?typeValue list("active_compression_13") ?session sess)
    maeSetEnvOption("active_compression_13" ?options list(list("modelFiles" list(list("/tools/designkits/NCSU/FreePDK4514/ncsu_basekit/models/hspice/tran_models/models_nom/NMOS_VTH.inc" "")))) ?session sess)
    maeSetSimOption("active_compression_13" ?options list(list("temp" "27") list("tnom" "27") list("reltol" "1e-05") list("vabstol" "1e-9") list("iabstol" "1e-13") list("gmin" "1e-12") list("digits" "12")) ?session sess)
    testHandle=maeGetTestSession("active_compression_13" ?session sess)
    asiSetHighPerformanceOptionVal(testHandle 'uniMode "Spectre")
    unless(equal(asiGetHighPerformanceOptionVal(testHandle 'uniMode) "Spectre") error("Cannot set ordinary Spectre engine.\n"))
    asiSetHighPerformanceOptionVal(testHandle 'errorLevel "Do not override")
    unless(maeSetAnalysis("active_compression_13" "tran" ?enable t ?options list(list("stop" "2.5e-08") list("maxstep" "2e-12") list("strobeperiod" "5e-12") list("errpreset" "conservative")) ?session sess) error("Could not configure active_compression_13/tran.\n"))
    maeAddOutput("rf" "active_compression_13" ?outputType "net" ?signalName "/rf" ?save t ?plot nil ?session sess)
    maeAddOutput("rfdrive" "active_compression_13" ?outputType "net" ?signalName "/rfdrive" ?save t ?plot nil ?session sess)
    maeAddOutput("outp" "active_compression_13" ?outputType "net" ?signalName "/outp" ?save t ?plot nil ?session sess)
    maeAddOutput("outn" "active_compression_13" ?outputType "net" ?signalName "/outn" ?save t ?plot nil ?session sess)
    maeAddOutput("lop" "active_compression_13" ?outputType "net" ?signalName "/lop" ?save t ?plot nil ?session sess)
    maeAddOutput("lon" "active_compression_13" ?outputType "net" ?signalName "/lon" ?save t ?plot nil ?session sess)
    maeAddOutput("tail" "active_compression_13" ?outputType "net" ?signalName "/tail" ?save t ?plot nil ?session sess)
    maeAddOutput("vdd_current" "active_compression_13" ?outputType "terminal" ?signalName "/VDD/PLUS" ?save t ?plot nil ?session sess)
    unless(member("active_two_tone_00" maeGetSetup(?session sess))
      maeCreateTest("active_two_tone_00" ?lib "HW09_Mixers" ?cell "active_tb" ?view "schematic" ?simulator "spectre" ?session sess))
    maeSetVar("pinDbm" "-50" ?typeName "test" ?typeValue list("active_two_tone_00") ?session sess)
    maeSetVar("fRF" "5790000000.0" ?typeName "test" ?typeValue list("active_two_tone_00") ?session sess)
    maeSetVar("fRF2" "5810000000.0" ?typeName "test" ?typeValue list("active_two_tone_00") ?session sess)
    maeSetVar("tone2Scale" "1" ?typeName "test" ?typeValue list("active_two_tone_00") ?session sess)
    maeSetVar("rfScale" "1" ?typeName "test" ?typeValue list("active_two_tone_00") ?session sess)
    maeSetEnvOption("active_two_tone_00" ?options list(list("modelFiles" list(list("/tools/designkits/NCSU/FreePDK4514/ncsu_basekit/models/hspice/tran_models/models_nom/NMOS_VTH.inc" "")))) ?session sess)
    maeSetSimOption("active_two_tone_00" ?options list(list("temp" "27") list("tnom" "27") list("reltol" "1e-05") list("vabstol" "1e-9") list("iabstol" "1e-13") list("gmin" "1e-12") list("digits" "12")) ?session sess)
    testHandle=maeGetTestSession("active_two_tone_00" ?session sess)
    asiSetHighPerformanceOptionVal(testHandle 'uniMode "Spectre")
    unless(equal(asiGetHighPerformanceOptionVal(testHandle 'uniMode) "Spectre") error("Cannot set ordinary Spectre engine.\n"))
    asiSetHighPerformanceOptionVal(testHandle 'errorLevel "Do not override")
    unless(maeSetAnalysis("active_two_tone_00" "tran" ?enable t ?options list(list("stop" "1.2e-07") list("maxstep" "2e-12") list("strobeperiod" "5e-12") list("errpreset" "conservative")) ?session sess) error("Could not configure active_two_tone_00/tran.\n"))
    maeAddOutput("rf" "active_two_tone_00" ?outputType "net" ?signalName "/rf" ?save t ?plot nil ?session sess)
    maeAddOutput("rfdrive" "active_two_tone_00" ?outputType "net" ?signalName "/rfdrive" ?save t ?plot nil ?session sess)
    maeAddOutput("outp" "active_two_tone_00" ?outputType "net" ?signalName "/outp" ?save t ?plot nil ?session sess)
    maeAddOutput("outn" "active_two_tone_00" ?outputType "net" ?signalName "/outn" ?save t ?plot nil ?session sess)
    maeAddOutput("lop" "active_two_tone_00" ?outputType "net" ?signalName "/lop" ?save t ?plot nil ?session sess)
    maeAddOutput("lon" "active_two_tone_00" ?outputType "net" ?signalName "/lon" ?save t ?plot nil ?session sess)
    maeAddOutput("tail" "active_two_tone_00" ?outputType "net" ?signalName "/tail" ?save t ?plot nil ?session sess)
    maeAddOutput("vdd_current" "active_two_tone_00" ?outputType "terminal" ?signalName "/VDD/PLUS" ?save t ?plot nil ?session sess)
    unless(member("active_two_tone_01" maeGetSetup(?session sess))
      maeCreateTest("active_two_tone_01" ?lib "HW09_Mixers" ?cell "active_tb" ?view "schematic" ?simulator "spectre" ?session sess))
    maeSetVar("pinDbm" "-45" ?typeName "test" ?typeValue list("active_two_tone_01") ?session sess)
    maeSetVar("fRF" "5790000000.0" ?typeName "test" ?typeValue list("active_two_tone_01") ?session sess)
    maeSetVar("fRF2" "5810000000.0" ?typeName "test" ?typeValue list("active_two_tone_01") ?session sess)
    maeSetVar("tone2Scale" "1" ?typeName "test" ?typeValue list("active_two_tone_01") ?session sess)
    maeSetVar("rfScale" "1" ?typeName "test" ?typeValue list("active_two_tone_01") ?session sess)
    maeSetEnvOption("active_two_tone_01" ?options list(list("modelFiles" list(list("/tools/designkits/NCSU/FreePDK4514/ncsu_basekit/models/hspice/tran_models/models_nom/NMOS_VTH.inc" "")))) ?session sess)
    maeSetSimOption("active_two_tone_01" ?options list(list("temp" "27") list("tnom" "27") list("reltol" "1e-05") list("vabstol" "1e-9") list("iabstol" "1e-13") list("gmin" "1e-12") list("digits" "12")) ?session sess)
    testHandle=maeGetTestSession("active_two_tone_01" ?session sess)
    asiSetHighPerformanceOptionVal(testHandle 'uniMode "Spectre")
    unless(equal(asiGetHighPerformanceOptionVal(testHandle 'uniMode) "Spectre") error("Cannot set ordinary Spectre engine.\n"))
    asiSetHighPerformanceOptionVal(testHandle 'errorLevel "Do not override")
    unless(maeSetAnalysis("active_two_tone_01" "tran" ?enable t ?options list(list("stop" "1.2e-07") list("maxstep" "2e-12") list("strobeperiod" "5e-12") list("errpreset" "conservative")) ?session sess) error("Could not configure active_two_tone_01/tran.\n"))
    maeAddOutput("rf" "active_two_tone_01" ?outputType "net" ?signalName "/rf" ?save t ?plot nil ?session sess)
    maeAddOutput("rfdrive" "active_two_tone_01" ?outputType "net" ?signalName "/rfdrive" ?save t ?plot nil ?session sess)
    maeAddOutput("outp" "active_two_tone_01" ?outputType "net" ?signalName "/outp" ?save t ?plot nil ?session sess)
    maeAddOutput("outn" "active_two_tone_01" ?outputType "net" ?signalName "/outn" ?save t ?plot nil ?session sess)
    maeAddOutput("lop" "active_two_tone_01" ?outputType "net" ?signalName "/lop" ?save t ?plot nil ?session sess)
    maeAddOutput("lon" "active_two_tone_01" ?outputType "net" ?signalName "/lon" ?save t ?plot nil ?session sess)
    maeAddOutput("tail" "active_two_tone_01" ?outputType "net" ?signalName "/tail" ?save t ?plot nil ?session sess)
    maeAddOutput("vdd_current" "active_two_tone_01" ?outputType "terminal" ?signalName "/VDD/PLUS" ?save t ?plot nil ?session sess)
    unless(member("active_two_tone_02" maeGetSetup(?session sess))
      maeCreateTest("active_two_tone_02" ?lib "HW09_Mixers" ?cell "active_tb" ?view "schematic" ?simulator "spectre" ?session sess))
    maeSetVar("pinDbm" "-40" ?typeName "test" ?typeValue list("active_two_tone_02") ?session sess)
    maeSetVar("fRF" "5790000000.0" ?typeName "test" ?typeValue list("active_two_tone_02") ?session sess)
    maeSetVar("fRF2" "5810000000.0" ?typeName "test" ?typeValue list("active_two_tone_02") ?session sess)
    maeSetVar("tone2Scale" "1" ?typeName "test" ?typeValue list("active_two_tone_02") ?session sess)
    maeSetVar("rfScale" "1" ?typeName "test" ?typeValue list("active_two_tone_02") ?session sess)
    maeSetEnvOption("active_two_tone_02" ?options list(list("modelFiles" list(list("/tools/designkits/NCSU/FreePDK4514/ncsu_basekit/models/hspice/tran_models/models_nom/NMOS_VTH.inc" "")))) ?session sess)
    maeSetSimOption("active_two_tone_02" ?options list(list("temp" "27") list("tnom" "27") list("reltol" "1e-05") list("vabstol" "1e-9") list("iabstol" "1e-13") list("gmin" "1e-12") list("digits" "12")) ?session sess)
    testHandle=maeGetTestSession("active_two_tone_02" ?session sess)
    asiSetHighPerformanceOptionVal(testHandle 'uniMode "Spectre")
    unless(equal(asiGetHighPerformanceOptionVal(testHandle 'uniMode) "Spectre") error("Cannot set ordinary Spectre engine.\n"))
    asiSetHighPerformanceOptionVal(testHandle 'errorLevel "Do not override")
    unless(maeSetAnalysis("active_two_tone_02" "tran" ?enable t ?options list(list("stop" "1.2e-07") list("maxstep" "2e-12") list("strobeperiod" "5e-12") list("errpreset" "conservative")) ?session sess) error("Could not configure active_two_tone_02/tran.\n"))
    maeAddOutput("rf" "active_two_tone_02" ?outputType "net" ?signalName "/rf" ?save t ?plot nil ?session sess)
    maeAddOutput("rfdrive" "active_two_tone_02" ?outputType "net" ?signalName "/rfdrive" ?save t ?plot nil ?session sess)
    maeAddOutput("outp" "active_two_tone_02" ?outputType "net" ?signalName "/outp" ?save t ?plot nil ?session sess)
    maeAddOutput("outn" "active_two_tone_02" ?outputType "net" ?signalName "/outn" ?save t ?plot nil ?session sess)
    maeAddOutput("lop" "active_two_tone_02" ?outputType "net" ?signalName "/lop" ?save t ?plot nil ?session sess)
    maeAddOutput("lon" "active_two_tone_02" ?outputType "net" ?signalName "/lon" ?save t ?plot nil ?session sess)
    maeAddOutput("tail" "active_two_tone_02" ?outputType "net" ?signalName "/tail" ?save t ?plot nil ?session sess)
    maeAddOutput("vdd_current" "active_two_tone_02" ?outputType "terminal" ?signalName "/VDD/PLUS" ?save t ?plot nil ?session sess)
    unless(member("active_two_tone_03" maeGetSetup(?session sess))
      maeCreateTest("active_two_tone_03" ?lib "HW09_Mixers" ?cell "active_tb" ?view "schematic" ?simulator "spectre" ?session sess))
    maeSetVar("pinDbm" "-35" ?typeName "test" ?typeValue list("active_two_tone_03") ?session sess)
    maeSetVar("fRF" "5790000000.0" ?typeName "test" ?typeValue list("active_two_tone_03") ?session sess)
    maeSetVar("fRF2" "5810000000.0" ?typeName "test" ?typeValue list("active_two_tone_03") ?session sess)
    maeSetVar("tone2Scale" "1" ?typeName "test" ?typeValue list("active_two_tone_03") ?session sess)
    maeSetVar("rfScale" "1" ?typeName "test" ?typeValue list("active_two_tone_03") ?session sess)
    maeSetEnvOption("active_two_tone_03" ?options list(list("modelFiles" list(list("/tools/designkits/NCSU/FreePDK4514/ncsu_basekit/models/hspice/tran_models/models_nom/NMOS_VTH.inc" "")))) ?session sess)
    maeSetSimOption("active_two_tone_03" ?options list(list("temp" "27") list("tnom" "27") list("reltol" "1e-05") list("vabstol" "1e-9") list("iabstol" "1e-13") list("gmin" "1e-12") list("digits" "12")) ?session sess)
    testHandle=maeGetTestSession("active_two_tone_03" ?session sess)
    asiSetHighPerformanceOptionVal(testHandle 'uniMode "Spectre")
    unless(equal(asiGetHighPerformanceOptionVal(testHandle 'uniMode) "Spectre") error("Cannot set ordinary Spectre engine.\n"))
    asiSetHighPerformanceOptionVal(testHandle 'errorLevel "Do not override")
    unless(maeSetAnalysis("active_two_tone_03" "tran" ?enable t ?options list(list("stop" "1.2e-07") list("maxstep" "2e-12") list("strobeperiod" "5e-12") list("errpreset" "conservative")) ?session sess) error("Could not configure active_two_tone_03/tran.\n"))
    maeAddOutput("rf" "active_two_tone_03" ?outputType "net" ?signalName "/rf" ?save t ?plot nil ?session sess)
    maeAddOutput("rfdrive" "active_two_tone_03" ?outputType "net" ?signalName "/rfdrive" ?save t ?plot nil ?session sess)
    maeAddOutput("outp" "active_two_tone_03" ?outputType "net" ?signalName "/outp" ?save t ?plot nil ?session sess)
    maeAddOutput("outn" "active_two_tone_03" ?outputType "net" ?signalName "/outn" ?save t ?plot nil ?session sess)
    maeAddOutput("lop" "active_two_tone_03" ?outputType "net" ?signalName "/lop" ?save t ?plot nil ?session sess)
    maeAddOutput("lon" "active_two_tone_03" ?outputType "net" ?signalName "/lon" ?save t ?plot nil ?session sess)
    maeAddOutput("tail" "active_two_tone_03" ?outputType "net" ?signalName "/tail" ?save t ?plot nil ?session sess)
    maeAddOutput("vdd_current" "active_two_tone_03" ?outputType "terminal" ?signalName "/VDD/PLUS" ?save t ?plot nil ?session sess)
    unless(member("active_two_tone_04" maeGetSetup(?session sess))
      maeCreateTest("active_two_tone_04" ?lib "HW09_Mixers" ?cell "active_tb" ?view "schematic" ?simulator "spectre" ?session sess))
    maeSetVar("pinDbm" "-30" ?typeName "test" ?typeValue list("active_two_tone_04") ?session sess)
    maeSetVar("fRF" "5790000000.0" ?typeName "test" ?typeValue list("active_two_tone_04") ?session sess)
    maeSetVar("fRF2" "5810000000.0" ?typeName "test" ?typeValue list("active_two_tone_04") ?session sess)
    maeSetVar("tone2Scale" "1" ?typeName "test" ?typeValue list("active_two_tone_04") ?session sess)
    maeSetVar("rfScale" "1" ?typeName "test" ?typeValue list("active_two_tone_04") ?session sess)
    maeSetEnvOption("active_two_tone_04" ?options list(list("modelFiles" list(list("/tools/designkits/NCSU/FreePDK4514/ncsu_basekit/models/hspice/tran_models/models_nom/NMOS_VTH.inc" "")))) ?session sess)
    maeSetSimOption("active_two_tone_04" ?options list(list("temp" "27") list("tnom" "27") list("reltol" "1e-05") list("vabstol" "1e-9") list("iabstol" "1e-13") list("gmin" "1e-12") list("digits" "12")) ?session sess)
    testHandle=maeGetTestSession("active_two_tone_04" ?session sess)
    asiSetHighPerformanceOptionVal(testHandle 'uniMode "Spectre")
    unless(equal(asiGetHighPerformanceOptionVal(testHandle 'uniMode) "Spectre") error("Cannot set ordinary Spectre engine.\n"))
    asiSetHighPerformanceOptionVal(testHandle 'errorLevel "Do not override")
    unless(maeSetAnalysis("active_two_tone_04" "tran" ?enable t ?options list(list("stop" "1.2e-07") list("maxstep" "2e-12") list("strobeperiod" "5e-12") list("errpreset" "conservative")) ?session sess) error("Could not configure active_two_tone_04/tran.\n"))
    maeAddOutput("rf" "active_two_tone_04" ?outputType "net" ?signalName "/rf" ?save t ?plot nil ?session sess)
    maeAddOutput("rfdrive" "active_two_tone_04" ?outputType "net" ?signalName "/rfdrive" ?save t ?plot nil ?session sess)
    maeAddOutput("outp" "active_two_tone_04" ?outputType "net" ?signalName "/outp" ?save t ?plot nil ?session sess)
    maeAddOutput("outn" "active_two_tone_04" ?outputType "net" ?signalName "/outn" ?save t ?plot nil ?session sess)
    maeAddOutput("lop" "active_two_tone_04" ?outputType "net" ?signalName "/lop" ?save t ?plot nil ?session sess)
    maeAddOutput("lon" "active_two_tone_04" ?outputType "net" ?signalName "/lon" ?save t ?plot nil ?session sess)
    maeAddOutput("tail" "active_two_tone_04" ?outputType "net" ?signalName "/tail" ?save t ?plot nil ?session sess)
    maeAddOutput("vdd_current" "active_two_tone_04" ?outputType "terminal" ?signalName "/VDD/PLUS" ?save t ?plot nil ?session sess)
    unless(member("active_two_tone_05" maeGetSetup(?session sess))
      maeCreateTest("active_two_tone_05" ?lib "HW09_Mixers" ?cell "active_tb" ?view "schematic" ?simulator "spectre" ?session sess))
    maeSetVar("pinDbm" "-25" ?typeName "test" ?typeValue list("active_two_tone_05") ?session sess)
    maeSetVar("fRF" "5790000000.0" ?typeName "test" ?typeValue list("active_two_tone_05") ?session sess)
    maeSetVar("fRF2" "5810000000.0" ?typeName "test" ?typeValue list("active_two_tone_05") ?session sess)
    maeSetVar("tone2Scale" "1" ?typeName "test" ?typeValue list("active_two_tone_05") ?session sess)
    maeSetVar("rfScale" "1" ?typeName "test" ?typeValue list("active_two_tone_05") ?session sess)
    maeSetEnvOption("active_two_tone_05" ?options list(list("modelFiles" list(list("/tools/designkits/NCSU/FreePDK4514/ncsu_basekit/models/hspice/tran_models/models_nom/NMOS_VTH.inc" "")))) ?session sess)
    maeSetSimOption("active_two_tone_05" ?options list(list("temp" "27") list("tnom" "27") list("reltol" "1e-05") list("vabstol" "1e-9") list("iabstol" "1e-13") list("gmin" "1e-12") list("digits" "12")) ?session sess)
    testHandle=maeGetTestSession("active_two_tone_05" ?session sess)
    asiSetHighPerformanceOptionVal(testHandle 'uniMode "Spectre")
    unless(equal(asiGetHighPerformanceOptionVal(testHandle 'uniMode) "Spectre") error("Cannot set ordinary Spectre engine.\n"))
    asiSetHighPerformanceOptionVal(testHandle 'errorLevel "Do not override")
    unless(maeSetAnalysis("active_two_tone_05" "tran" ?enable t ?options list(list("stop" "1.2e-07") list("maxstep" "2e-12") list("strobeperiod" "5e-12") list("errpreset" "conservative")) ?session sess) error("Could not configure active_two_tone_05/tran.\n"))
    maeAddOutput("rf" "active_two_tone_05" ?outputType "net" ?signalName "/rf" ?save t ?plot nil ?session sess)
    maeAddOutput("rfdrive" "active_two_tone_05" ?outputType "net" ?signalName "/rfdrive" ?save t ?plot nil ?session sess)
    maeAddOutput("outp" "active_two_tone_05" ?outputType "net" ?signalName "/outp" ?save t ?plot nil ?session sess)
    maeAddOutput("outn" "active_two_tone_05" ?outputType "net" ?signalName "/outn" ?save t ?plot nil ?session sess)
    maeAddOutput("lop" "active_two_tone_05" ?outputType "net" ?signalName "/lop" ?save t ?plot nil ?session sess)
    maeAddOutput("lon" "active_two_tone_05" ?outputType "net" ?signalName "/lon" ?save t ?plot nil ?session sess)
    maeAddOutput("tail" "active_two_tone_05" ?outputType "net" ?signalName "/tail" ?save t ?plot nil ?session sess)
    maeAddOutput("vdd_current" "active_two_tone_05" ?outputType "terminal" ?signalName "/VDD/PLUS" ?save t ?plot nil ?session sess)
    unless(member("active_two_tone_06" maeGetSetup(?session sess))
      maeCreateTest("active_two_tone_06" ?lib "HW09_Mixers" ?cell "active_tb" ?view "schematic" ?simulator "spectre" ?session sess))
    maeSetVar("pinDbm" "-20" ?typeName "test" ?typeValue list("active_two_tone_06") ?session sess)
    maeSetVar("fRF" "5790000000.0" ?typeName "test" ?typeValue list("active_two_tone_06") ?session sess)
    maeSetVar("fRF2" "5810000000.0" ?typeName "test" ?typeValue list("active_two_tone_06") ?session sess)
    maeSetVar("tone2Scale" "1" ?typeName "test" ?typeValue list("active_two_tone_06") ?session sess)
    maeSetVar("rfScale" "1" ?typeName "test" ?typeValue list("active_two_tone_06") ?session sess)
    maeSetEnvOption("active_two_tone_06" ?options list(list("modelFiles" list(list("/tools/designkits/NCSU/FreePDK4514/ncsu_basekit/models/hspice/tran_models/models_nom/NMOS_VTH.inc" "")))) ?session sess)
    maeSetSimOption("active_two_tone_06" ?options list(list("temp" "27") list("tnom" "27") list("reltol" "1e-05") list("vabstol" "1e-9") list("iabstol" "1e-13") list("gmin" "1e-12") list("digits" "12")) ?session sess)
    testHandle=maeGetTestSession("active_two_tone_06" ?session sess)
    asiSetHighPerformanceOptionVal(testHandle 'uniMode "Spectre")
    unless(equal(asiGetHighPerformanceOptionVal(testHandle 'uniMode) "Spectre") error("Cannot set ordinary Spectre engine.\n"))
    asiSetHighPerformanceOptionVal(testHandle 'errorLevel "Do not override")
    unless(maeSetAnalysis("active_two_tone_06" "tran" ?enable t ?options list(list("stop" "1.2e-07") list("maxstep" "2e-12") list("strobeperiod" "5e-12") list("errpreset" "conservative")) ?session sess) error("Could not configure active_two_tone_06/tran.\n"))
    maeAddOutput("rf" "active_two_tone_06" ?outputType "net" ?signalName "/rf" ?save t ?plot nil ?session sess)
    maeAddOutput("rfdrive" "active_two_tone_06" ?outputType "net" ?signalName "/rfdrive" ?save t ?plot nil ?session sess)
    maeAddOutput("outp" "active_two_tone_06" ?outputType "net" ?signalName "/outp" ?save t ?plot nil ?session sess)
    maeAddOutput("outn" "active_two_tone_06" ?outputType "net" ?signalName "/outn" ?save t ?plot nil ?session sess)
    maeAddOutput("lop" "active_two_tone_06" ?outputType "net" ?signalName "/lop" ?save t ?plot nil ?session sess)
    maeAddOutput("lon" "active_two_tone_06" ?outputType "net" ?signalName "/lon" ?save t ?plot nil ?session sess)
    maeAddOutput("tail" "active_two_tone_06" ?outputType "net" ?signalName "/tail" ?save t ?plot nil ?session sess)
    maeAddOutput("vdd_current" "active_two_tone_06" ?outputType "terminal" ?signalName "/VDD/PLUS" ?save t ?plot nil ?session sess)
    unless(member("active_two_tone_tight" maeGetSetup(?session sess))
      maeCreateTest("active_two_tone_tight" ?lib "HW09_Mixers" ?cell "active_tb" ?view "schematic" ?simulator "spectre" ?session sess))
    maeSetVar("pinDbm" "-35" ?typeName "test" ?typeValue list("active_two_tone_tight") ?session sess)
    maeSetVar("fRF" "5790000000.0" ?typeName "test" ?typeValue list("active_two_tone_tight") ?session sess)
    maeSetVar("fRF2" "5810000000.0" ?typeName "test" ?typeValue list("active_two_tone_tight") ?session sess)
    maeSetVar("tone2Scale" "1" ?typeName "test" ?typeValue list("active_two_tone_tight") ?session sess)
    maeSetVar("rfScale" "1" ?typeName "test" ?typeValue list("active_two_tone_tight") ?session sess)
    maeSetEnvOption("active_two_tone_tight" ?options list(list("modelFiles" list(list("/tools/designkits/NCSU/FreePDK4514/ncsu_basekit/models/hspice/tran_models/models_nom/NMOS_VTH.inc" "")))) ?session sess)
    maeSetSimOption("active_two_tone_tight" ?options list(list("temp" "27") list("tnom" "27") list("reltol" "1e-06") list("vabstol" "1e-9") list("iabstol" "1e-13") list("gmin" "1e-12") list("digits" "12")) ?session sess)
    testHandle=maeGetTestSession("active_two_tone_tight" ?session sess)
    asiSetHighPerformanceOptionVal(testHandle 'uniMode "Spectre")
    unless(equal(asiGetHighPerformanceOptionVal(testHandle 'uniMode) "Spectre") error("Cannot set ordinary Spectre engine.\n"))
    asiSetHighPerformanceOptionVal(testHandle 'errorLevel "Do not override")
    unless(maeSetAnalysis("active_two_tone_tight" "tran" ?enable t ?options list(list("stop" "1.2e-07") list("maxstep" "1e-12") list("strobeperiod" "5e-12") list("errpreset" "conservative")) ?session sess) error("Could not configure active_two_tone_tight/tran.\n"))
    maeAddOutput("rf" "active_two_tone_tight" ?outputType "net" ?signalName "/rf" ?save t ?plot nil ?session sess)
    maeAddOutput("rfdrive" "active_two_tone_tight" ?outputType "net" ?signalName "/rfdrive" ?save t ?plot nil ?session sess)
    maeAddOutput("outp" "active_two_tone_tight" ?outputType "net" ?signalName "/outp" ?save t ?plot nil ?session sess)
    maeAddOutput("outn" "active_two_tone_tight" ?outputType "net" ?signalName "/outn" ?save t ?plot nil ?session sess)
    maeAddOutput("lop" "active_two_tone_tight" ?outputType "net" ?signalName "/lop" ?save t ?plot nil ?session sess)
    maeAddOutput("lon" "active_two_tone_tight" ?outputType "net" ?signalName "/lon" ?save t ?plot nil ?session sess)
    maeAddOutput("tail" "active_two_tone_tight" ?outputType "net" ?signalName "/tail" ?save t ?plot nil ?session sess)
    maeAddOutput("vdd_current" "active_two_tone_tight" ?outputType "terminal" ?signalName "/VDD/PLUS" ?save t ?plot nil ?session sess)
    unless(member("passive_single_tone" maeGetSetup(?session sess))
      maeCreateTest("passive_single_tone" ?lib "HW09_Mixers" ?cell "passive_tb" ?view "schematic" ?simulator "spectre" ?session sess))
    maeSetVar("pinDbm" "-55" ?typeName "test" ?typeValue list("passive_single_tone") ?session sess)
    maeSetVar("fRF" "5800000000.0" ?typeName "test" ?typeValue list("passive_single_tone") ?session sess)
    maeSetVar("fRF2" "5800000000.0" ?typeName "test" ?typeValue list("passive_single_tone") ?session sess)
    maeSetVar("tone2Scale" "0" ?typeName "test" ?typeValue list("passive_single_tone") ?session sess)
    maeSetVar("rfScale" "1" ?typeName "test" ?typeValue list("passive_single_tone") ?session sess)
    maeSetEnvOption("passive_single_tone" ?options list(list("modelFiles" list(list("/tools/designkits/NCSU/FreePDK4514/ncsu_basekit/models/hspice/tran_models/models_nom/NMOS_VTH.inc" "")))) ?session sess)
    maeSetSimOption("passive_single_tone" ?options list(list("temp" "27") list("tnom" "27") list("reltol" "1e-05") list("vabstol" "1e-9") list("iabstol" "1e-13") list("gmin" "1e-12") list("digits" "12")) ?session sess)
    testHandle=maeGetTestSession("passive_single_tone" ?session sess)
    asiSetHighPerformanceOptionVal(testHandle 'uniMode "Spectre")
    unless(equal(asiGetHighPerformanceOptionVal(testHandle 'uniMode) "Spectre") error("Cannot set ordinary Spectre engine.\n"))
    asiSetHighPerformanceOptionVal(testHandle 'errorLevel "Do not override")
    unless(maeSetAnalysis("passive_single_tone" "tran" ?enable t ?options list(list("stop" "2.5e-08") list("maxstep" "2e-12") list("strobeperiod" "5e-12") list("errpreset" "conservative")) ?session sess) error("Could not configure passive_single_tone/tran.\n"))
    maeAddOutput("rf" "passive_single_tone" ?outputType "net" ?signalName "/rf" ?save t ?plot nil ?session sess)
    maeAddOutput("rfdrive" "passive_single_tone" ?outputType "net" ?signalName "/rfdrive" ?save t ?plot nil ?session sess)
    maeAddOutput("outp" "passive_single_tone" ?outputType "net" ?signalName "/outp" ?save t ?plot nil ?session sess)
    maeAddOutput("outn" "passive_single_tone" ?outputType "net" ?signalName "/outn" ?save t ?plot nil ?session sess)
    maeAddOutput("lop" "passive_single_tone" ?outputType "net" ?signalName "/lop" ?save t ?plot nil ?session sess)
    maeAddOutput("lon" "passive_single_tone" ?outputType "net" ?signalName "/lon" ?save t ?plot nil ?session sess)
    unless(member("passive_single_window_check" maeGetSetup(?session sess))
      maeCreateTest("passive_single_window_check" ?lib "HW09_Mixers" ?cell "passive_tb" ?view "schematic" ?simulator "spectre" ?session sess))
    maeSetVar("pinDbm" "-55" ?typeName "test" ?typeValue list("passive_single_window_check") ?session sess)
    maeSetVar("fRF" "5800000000.0" ?typeName "test" ?typeValue list("passive_single_window_check") ?session sess)
    maeSetVar("fRF2" "5800000000.0" ?typeName "test" ?typeValue list("passive_single_window_check") ?session sess)
    maeSetVar("tone2Scale" "0" ?typeName "test" ?typeValue list("passive_single_window_check") ?session sess)
    maeSetVar("rfScale" "1" ?typeName "test" ?typeValue list("passive_single_window_check") ?session sess)
    maeSetEnvOption("passive_single_window_check" ?options list(list("modelFiles" list(list("/tools/designkits/NCSU/FreePDK4514/ncsu_basekit/models/hspice/tran_models/models_nom/NMOS_VTH.inc" "")))) ?session sess)
    maeSetSimOption("passive_single_window_check" ?options list(list("temp" "27") list("tnom" "27") list("reltol" "1e-05") list("vabstol" "1e-9") list("iabstol" "1e-13") list("gmin" "1e-12") list("digits" "12")) ?session sess)
    testHandle=maeGetTestSession("passive_single_window_check" ?session sess)
    asiSetHighPerformanceOptionVal(testHandle 'uniMode "Spectre")
    unless(equal(asiGetHighPerformanceOptionVal(testHandle 'uniMode) "Spectre") error("Cannot set ordinary Spectre engine.\n"))
    asiSetHighPerformanceOptionVal(testHandle 'errorLevel "Do not override")
    unless(maeSetAnalysis("passive_single_window_check" "tran" ?enable t ?options list(list("stop" "1.2e-07") list("maxstep" "2e-12") list("strobeperiod" "5e-12") list("errpreset" "conservative")) ?session sess) error("Could not configure passive_single_window_check/tran.\n"))
    maeAddOutput("rf" "passive_single_window_check" ?outputType "net" ?signalName "/rf" ?save t ?plot nil ?session sess)
    maeAddOutput("rfdrive" "passive_single_window_check" ?outputType "net" ?signalName "/rfdrive" ?save t ?plot nil ?session sess)
    maeAddOutput("outp" "passive_single_window_check" ?outputType "net" ?signalName "/outp" ?save t ?plot nil ?session sess)
    maeAddOutput("outn" "passive_single_window_check" ?outputType "net" ?signalName "/outn" ?save t ?plot nil ?session sess)
    maeAddOutput("lop" "passive_single_window_check" ?outputType "net" ?signalName "/lop" ?save t ?plot nil ?session sess)
    maeAddOutput("lon" "passive_single_window_check" ?outputType "net" ?signalName "/lon" ?save t ?plot nil ?session sess)
    unless(member("passive_compression_00" maeGetSetup(?session sess))
      maeCreateTest("passive_compression_00" ?lib "HW09_Mixers" ?cell "passive_tb" ?view "schematic" ?simulator "spectre" ?session sess))
    maeSetVar("pinDbm" "-60" ?typeName "test" ?typeValue list("passive_compression_00") ?session sess)
    maeSetVar("fRF" "5800000000.0" ?typeName "test" ?typeValue list("passive_compression_00") ?session sess)
    maeSetVar("fRF2" "5800000000.0" ?typeName "test" ?typeValue list("passive_compression_00") ?session sess)
    maeSetVar("tone2Scale" "0" ?typeName "test" ?typeValue list("passive_compression_00") ?session sess)
    maeSetVar("rfScale" "1" ?typeName "test" ?typeValue list("passive_compression_00") ?session sess)
    maeSetEnvOption("passive_compression_00" ?options list(list("modelFiles" list(list("/tools/designkits/NCSU/FreePDK4514/ncsu_basekit/models/hspice/tran_models/models_nom/NMOS_VTH.inc" "")))) ?session sess)
    maeSetSimOption("passive_compression_00" ?options list(list("temp" "27") list("tnom" "27") list("reltol" "1e-05") list("vabstol" "1e-9") list("iabstol" "1e-13") list("gmin" "1e-12") list("digits" "12")) ?session sess)
    testHandle=maeGetTestSession("passive_compression_00" ?session sess)
    asiSetHighPerformanceOptionVal(testHandle 'uniMode "Spectre")
    unless(equal(asiGetHighPerformanceOptionVal(testHandle 'uniMode) "Spectre") error("Cannot set ordinary Spectre engine.\n"))
    asiSetHighPerformanceOptionVal(testHandle 'errorLevel "Do not override")
    unless(maeSetAnalysis("passive_compression_00" "tran" ?enable t ?options list(list("stop" "2.5e-08") list("maxstep" "2e-12") list("strobeperiod" "5e-12") list("errpreset" "conservative")) ?session sess) error("Could not configure passive_compression_00/tran.\n"))
    maeAddOutput("rf" "passive_compression_00" ?outputType "net" ?signalName "/rf" ?save t ?plot nil ?session sess)
    maeAddOutput("rfdrive" "passive_compression_00" ?outputType "net" ?signalName "/rfdrive" ?save t ?plot nil ?session sess)
    maeAddOutput("outp" "passive_compression_00" ?outputType "net" ?signalName "/outp" ?save t ?plot nil ?session sess)
    maeAddOutput("outn" "passive_compression_00" ?outputType "net" ?signalName "/outn" ?save t ?plot nil ?session sess)
    maeAddOutput("lop" "passive_compression_00" ?outputType "net" ?signalName "/lop" ?save t ?plot nil ?session sess)
    maeAddOutput("lon" "passive_compression_00" ?outputType "net" ?signalName "/lon" ?save t ?plot nil ?session sess)
    unless(member("passive_compression_01" maeGetSetup(?session sess))
      maeCreateTest("passive_compression_01" ?lib "HW09_Mixers" ?cell "passive_tb" ?view "schematic" ?simulator "spectre" ?session sess))
    maeSetVar("pinDbm" "-50" ?typeName "test" ?typeValue list("passive_compression_01") ?session sess)
    maeSetVar("fRF" "5800000000.0" ?typeName "test" ?typeValue list("passive_compression_01") ?session sess)
    maeSetVar("fRF2" "5800000000.0" ?typeName "test" ?typeValue list("passive_compression_01") ?session sess)
    maeSetVar("tone2Scale" "0" ?typeName "test" ?typeValue list("passive_compression_01") ?session sess)
    maeSetVar("rfScale" "1" ?typeName "test" ?typeValue list("passive_compression_01") ?session sess)
    maeSetEnvOption("passive_compression_01" ?options list(list("modelFiles" list(list("/tools/designkits/NCSU/FreePDK4514/ncsu_basekit/models/hspice/tran_models/models_nom/NMOS_VTH.inc" "")))) ?session sess)
    maeSetSimOption("passive_compression_01" ?options list(list("temp" "27") list("tnom" "27") list("reltol" "1e-05") list("vabstol" "1e-9") list("iabstol" "1e-13") list("gmin" "1e-12") list("digits" "12")) ?session sess)
    testHandle=maeGetTestSession("passive_compression_01" ?session sess)
    asiSetHighPerformanceOptionVal(testHandle 'uniMode "Spectre")
    unless(equal(asiGetHighPerformanceOptionVal(testHandle 'uniMode) "Spectre") error("Cannot set ordinary Spectre engine.\n"))
    asiSetHighPerformanceOptionVal(testHandle 'errorLevel "Do not override")
    unless(maeSetAnalysis("passive_compression_01" "tran" ?enable t ?options list(list("stop" "2.5e-08") list("maxstep" "2e-12") list("strobeperiod" "5e-12") list("errpreset" "conservative")) ?session sess) error("Could not configure passive_compression_01/tran.\n"))
    maeAddOutput("rf" "passive_compression_01" ?outputType "net" ?signalName "/rf" ?save t ?plot nil ?session sess)
    maeAddOutput("rfdrive" "passive_compression_01" ?outputType "net" ?signalName "/rfdrive" ?save t ?plot nil ?session sess)
    maeAddOutput("outp" "passive_compression_01" ?outputType "net" ?signalName "/outp" ?save t ?plot nil ?session sess)
    maeAddOutput("outn" "passive_compression_01" ?outputType "net" ?signalName "/outn" ?save t ?plot nil ?session sess)
    maeAddOutput("lop" "passive_compression_01" ?outputType "net" ?signalName "/lop" ?save t ?plot nil ?session sess)
    maeAddOutput("lon" "passive_compression_01" ?outputType "net" ?signalName "/lon" ?save t ?plot nil ?session sess)
    unless(member("passive_compression_02" maeGetSetup(?session sess))
      maeCreateTest("passive_compression_02" ?lib "HW09_Mixers" ?cell "passive_tb" ?view "schematic" ?simulator "spectre" ?session sess))
    maeSetVar("pinDbm" "-40" ?typeName "test" ?typeValue list("passive_compression_02") ?session sess)
    maeSetVar("fRF" "5800000000.0" ?typeName "test" ?typeValue list("passive_compression_02") ?session sess)
    maeSetVar("fRF2" "5800000000.0" ?typeName "test" ?typeValue list("passive_compression_02") ?session sess)
    maeSetVar("tone2Scale" "0" ?typeName "test" ?typeValue list("passive_compression_02") ?session sess)
    maeSetVar("rfScale" "1" ?typeName "test" ?typeValue list("passive_compression_02") ?session sess)
    maeSetEnvOption("passive_compression_02" ?options list(list("modelFiles" list(list("/tools/designkits/NCSU/FreePDK4514/ncsu_basekit/models/hspice/tran_models/models_nom/NMOS_VTH.inc" "")))) ?session sess)
    maeSetSimOption("passive_compression_02" ?options list(list("temp" "27") list("tnom" "27") list("reltol" "1e-05") list("vabstol" "1e-9") list("iabstol" "1e-13") list("gmin" "1e-12") list("digits" "12")) ?session sess)
    testHandle=maeGetTestSession("passive_compression_02" ?session sess)
    asiSetHighPerformanceOptionVal(testHandle 'uniMode "Spectre")
    unless(equal(asiGetHighPerformanceOptionVal(testHandle 'uniMode) "Spectre") error("Cannot set ordinary Spectre engine.\n"))
    asiSetHighPerformanceOptionVal(testHandle 'errorLevel "Do not override")
    unless(maeSetAnalysis("passive_compression_02" "tran" ?enable t ?options list(list("stop" "2.5e-08") list("maxstep" "2e-12") list("strobeperiod" "5e-12") list("errpreset" "conservative")) ?session sess) error("Could not configure passive_compression_02/tran.\n"))
    maeAddOutput("rf" "passive_compression_02" ?outputType "net" ?signalName "/rf" ?save t ?plot nil ?session sess)
    maeAddOutput("rfdrive" "passive_compression_02" ?outputType "net" ?signalName "/rfdrive" ?save t ?plot nil ?session sess)
    maeAddOutput("outp" "passive_compression_02" ?outputType "net" ?signalName "/outp" ?save t ?plot nil ?session sess)
    maeAddOutput("outn" "passive_compression_02" ?outputType "net" ?signalName "/outn" ?save t ?plot nil ?session sess)
    maeAddOutput("lop" "passive_compression_02" ?outputType "net" ?signalName "/lop" ?save t ?plot nil ?session sess)
    maeAddOutput("lon" "passive_compression_02" ?outputType "net" ?signalName "/lon" ?save t ?plot nil ?session sess)
    unless(member("passive_compression_03" maeGetSetup(?session sess))
      maeCreateTest("passive_compression_03" ?lib "HW09_Mixers" ?cell "passive_tb" ?view "schematic" ?simulator "spectre" ?session sess))
    maeSetVar("pinDbm" "-35" ?typeName "test" ?typeValue list("passive_compression_03") ?session sess)
    maeSetVar("fRF" "5800000000.0" ?typeName "test" ?typeValue list("passive_compression_03") ?session sess)
    maeSetVar("fRF2" "5800000000.0" ?typeName "test" ?typeValue list("passive_compression_03") ?session sess)
    maeSetVar("tone2Scale" "0" ?typeName "test" ?typeValue list("passive_compression_03") ?session sess)
    maeSetVar("rfScale" "1" ?typeName "test" ?typeValue list("passive_compression_03") ?session sess)
    maeSetEnvOption("passive_compression_03" ?options list(list("modelFiles" list(list("/tools/designkits/NCSU/FreePDK4514/ncsu_basekit/models/hspice/tran_models/models_nom/NMOS_VTH.inc" "")))) ?session sess)
    maeSetSimOption("passive_compression_03" ?options list(list("temp" "27") list("tnom" "27") list("reltol" "1e-05") list("vabstol" "1e-9") list("iabstol" "1e-13") list("gmin" "1e-12") list("digits" "12")) ?session sess)
    testHandle=maeGetTestSession("passive_compression_03" ?session sess)
    asiSetHighPerformanceOptionVal(testHandle 'uniMode "Spectre")
    unless(equal(asiGetHighPerformanceOptionVal(testHandle 'uniMode) "Spectre") error("Cannot set ordinary Spectre engine.\n"))
    asiSetHighPerformanceOptionVal(testHandle 'errorLevel "Do not override")
    unless(maeSetAnalysis("passive_compression_03" "tran" ?enable t ?options list(list("stop" "2.5e-08") list("maxstep" "2e-12") list("strobeperiod" "5e-12") list("errpreset" "conservative")) ?session sess) error("Could not configure passive_compression_03/tran.\n"))
    maeAddOutput("rf" "passive_compression_03" ?outputType "net" ?signalName "/rf" ?save t ?plot nil ?session sess)
    maeAddOutput("rfdrive" "passive_compression_03" ?outputType "net" ?signalName "/rfdrive" ?save t ?plot nil ?session sess)
    maeAddOutput("outp" "passive_compression_03" ?outputType "net" ?signalName "/outp" ?save t ?plot nil ?session sess)
    maeAddOutput("outn" "passive_compression_03" ?outputType "net" ?signalName "/outn" ?save t ?plot nil ?session sess)
    maeAddOutput("lop" "passive_compression_03" ?outputType "net" ?signalName "/lop" ?save t ?plot nil ?session sess)
    maeAddOutput("lon" "passive_compression_03" ?outputType "net" ?signalName "/lon" ?save t ?plot nil ?session sess)
    unless(member("passive_compression_04" maeGetSetup(?session sess))
      maeCreateTest("passive_compression_04" ?lib "HW09_Mixers" ?cell "passive_tb" ?view "schematic" ?simulator "spectre" ?session sess))
    maeSetVar("pinDbm" "-30" ?typeName "test" ?typeValue list("passive_compression_04") ?session sess)
    maeSetVar("fRF" "5800000000.0" ?typeName "test" ?typeValue list("passive_compression_04") ?session sess)
    maeSetVar("fRF2" "5800000000.0" ?typeName "test" ?typeValue list("passive_compression_04") ?session sess)
    maeSetVar("tone2Scale" "0" ?typeName "test" ?typeValue list("passive_compression_04") ?session sess)
    maeSetVar("rfScale" "1" ?typeName "test" ?typeValue list("passive_compression_04") ?session sess)
    maeSetEnvOption("passive_compression_04" ?options list(list("modelFiles" list(list("/tools/designkits/NCSU/FreePDK4514/ncsu_basekit/models/hspice/tran_models/models_nom/NMOS_VTH.inc" "")))) ?session sess)
    maeSetSimOption("passive_compression_04" ?options list(list("temp" "27") list("tnom" "27") list("reltol" "1e-05") list("vabstol" "1e-9") list("iabstol" "1e-13") list("gmin" "1e-12") list("digits" "12")) ?session sess)
    testHandle=maeGetTestSession("passive_compression_04" ?session sess)
    asiSetHighPerformanceOptionVal(testHandle 'uniMode "Spectre")
    unless(equal(asiGetHighPerformanceOptionVal(testHandle 'uniMode) "Spectre") error("Cannot set ordinary Spectre engine.\n"))
    asiSetHighPerformanceOptionVal(testHandle 'errorLevel "Do not override")
    unless(maeSetAnalysis("passive_compression_04" "tran" ?enable t ?options list(list("stop" "2.5e-08") list("maxstep" "2e-12") list("strobeperiod" "5e-12") list("errpreset" "conservative")) ?session sess) error("Could not configure passive_compression_04/tran.\n"))
    maeAddOutput("rf" "passive_compression_04" ?outputType "net" ?signalName "/rf" ?save t ?plot nil ?session sess)
    maeAddOutput("rfdrive" "passive_compression_04" ?outputType "net" ?signalName "/rfdrive" ?save t ?plot nil ?session sess)
    maeAddOutput("outp" "passive_compression_04" ?outputType "net" ?signalName "/outp" ?save t ?plot nil ?session sess)
    maeAddOutput("outn" "passive_compression_04" ?outputType "net" ?signalName "/outn" ?save t ?plot nil ?session sess)
    maeAddOutput("lop" "passive_compression_04" ?outputType "net" ?signalName "/lop" ?save t ?plot nil ?session sess)
    maeAddOutput("lon" "passive_compression_04" ?outputType "net" ?signalName "/lon" ?save t ?plot nil ?session sess)
    unless(member("passive_compression_05" maeGetSetup(?session sess))
      maeCreateTest("passive_compression_05" ?lib "HW09_Mixers" ?cell "passive_tb" ?view "schematic" ?simulator "spectre" ?session sess))
    maeSetVar("pinDbm" "-25" ?typeName "test" ?typeValue list("passive_compression_05") ?session sess)
    maeSetVar("fRF" "5800000000.0" ?typeName "test" ?typeValue list("passive_compression_05") ?session sess)
    maeSetVar("fRF2" "5800000000.0" ?typeName "test" ?typeValue list("passive_compression_05") ?session sess)
    maeSetVar("tone2Scale" "0" ?typeName "test" ?typeValue list("passive_compression_05") ?session sess)
    maeSetVar("rfScale" "1" ?typeName "test" ?typeValue list("passive_compression_05") ?session sess)
    maeSetEnvOption("passive_compression_05" ?options list(list("modelFiles" list(list("/tools/designkits/NCSU/FreePDK4514/ncsu_basekit/models/hspice/tran_models/models_nom/NMOS_VTH.inc" "")))) ?session sess)
    maeSetSimOption("passive_compression_05" ?options list(list("temp" "27") list("tnom" "27") list("reltol" "1e-05") list("vabstol" "1e-9") list("iabstol" "1e-13") list("gmin" "1e-12") list("digits" "12")) ?session sess)
    testHandle=maeGetTestSession("passive_compression_05" ?session sess)
    asiSetHighPerformanceOptionVal(testHandle 'uniMode "Spectre")
    unless(equal(asiGetHighPerformanceOptionVal(testHandle 'uniMode) "Spectre") error("Cannot set ordinary Spectre engine.\n"))
    asiSetHighPerformanceOptionVal(testHandle 'errorLevel "Do not override")
    unless(maeSetAnalysis("passive_compression_05" "tran" ?enable t ?options list(list("stop" "2.5e-08") list("maxstep" "2e-12") list("strobeperiod" "5e-12") list("errpreset" "conservative")) ?session sess) error("Could not configure passive_compression_05/tran.\n"))
    maeAddOutput("rf" "passive_compression_05" ?outputType "net" ?signalName "/rf" ?save t ?plot nil ?session sess)
    maeAddOutput("rfdrive" "passive_compression_05" ?outputType "net" ?signalName "/rfdrive" ?save t ?plot nil ?session sess)
    maeAddOutput("outp" "passive_compression_05" ?outputType "net" ?signalName "/outp" ?save t ?plot nil ?session sess)
    maeAddOutput("outn" "passive_compression_05" ?outputType "net" ?signalName "/outn" ?save t ?plot nil ?session sess)
    maeAddOutput("lop" "passive_compression_05" ?outputType "net" ?signalName "/lop" ?save t ?plot nil ?session sess)
    maeAddOutput("lon" "passive_compression_05" ?outputType "net" ?signalName "/lon" ?save t ?plot nil ?session sess)
    unless(member("passive_compression_06" maeGetSetup(?session sess))
      maeCreateTest("passive_compression_06" ?lib "HW09_Mixers" ?cell "passive_tb" ?view "schematic" ?simulator "spectre" ?session sess))
    maeSetVar("pinDbm" "-20" ?typeName "test" ?typeValue list("passive_compression_06") ?session sess)
    maeSetVar("fRF" "5800000000.0" ?typeName "test" ?typeValue list("passive_compression_06") ?session sess)
    maeSetVar("fRF2" "5800000000.0" ?typeName "test" ?typeValue list("passive_compression_06") ?session sess)
    maeSetVar("tone2Scale" "0" ?typeName "test" ?typeValue list("passive_compression_06") ?session sess)
    maeSetVar("rfScale" "1" ?typeName "test" ?typeValue list("passive_compression_06") ?session sess)
    maeSetEnvOption("passive_compression_06" ?options list(list("modelFiles" list(list("/tools/designkits/NCSU/FreePDK4514/ncsu_basekit/models/hspice/tran_models/models_nom/NMOS_VTH.inc" "")))) ?session sess)
    maeSetSimOption("passive_compression_06" ?options list(list("temp" "27") list("tnom" "27") list("reltol" "1e-05") list("vabstol" "1e-9") list("iabstol" "1e-13") list("gmin" "1e-12") list("digits" "12")) ?session sess)
    testHandle=maeGetTestSession("passive_compression_06" ?session sess)
    asiSetHighPerformanceOptionVal(testHandle 'uniMode "Spectre")
    unless(equal(asiGetHighPerformanceOptionVal(testHandle 'uniMode) "Spectre") error("Cannot set ordinary Spectre engine.\n"))
    asiSetHighPerformanceOptionVal(testHandle 'errorLevel "Do not override")
    unless(maeSetAnalysis("passive_compression_06" "tran" ?enable t ?options list(list("stop" "2.5e-08") list("maxstep" "2e-12") list("strobeperiod" "5e-12") list("errpreset" "conservative")) ?session sess) error("Could not configure passive_compression_06/tran.\n"))
    maeAddOutput("rf" "passive_compression_06" ?outputType "net" ?signalName "/rf" ?save t ?plot nil ?session sess)
    maeAddOutput("rfdrive" "passive_compression_06" ?outputType "net" ?signalName "/rfdrive" ?save t ?plot nil ?session sess)
    maeAddOutput("outp" "passive_compression_06" ?outputType "net" ?signalName "/outp" ?save t ?plot nil ?session sess)
    maeAddOutput("outn" "passive_compression_06" ?outputType "net" ?signalName "/outn" ?save t ?plot nil ?session sess)
    maeAddOutput("lop" "passive_compression_06" ?outputType "net" ?signalName "/lop" ?save t ?plot nil ?session sess)
    maeAddOutput("lon" "passive_compression_06" ?outputType "net" ?signalName "/lon" ?save t ?plot nil ?session sess)
    unless(member("passive_compression_07" maeGetSetup(?session sess))
      maeCreateTest("passive_compression_07" ?lib "HW09_Mixers" ?cell "passive_tb" ?view "schematic" ?simulator "spectre" ?session sess))
    maeSetVar("pinDbm" "-17.5" ?typeName "test" ?typeValue list("passive_compression_07") ?session sess)
    maeSetVar("fRF" "5800000000.0" ?typeName "test" ?typeValue list("passive_compression_07") ?session sess)
    maeSetVar("fRF2" "5800000000.0" ?typeName "test" ?typeValue list("passive_compression_07") ?session sess)
    maeSetVar("tone2Scale" "0" ?typeName "test" ?typeValue list("passive_compression_07") ?session sess)
    maeSetVar("rfScale" "1" ?typeName "test" ?typeValue list("passive_compression_07") ?session sess)
    maeSetEnvOption("passive_compression_07" ?options list(list("modelFiles" list(list("/tools/designkits/NCSU/FreePDK4514/ncsu_basekit/models/hspice/tran_models/models_nom/NMOS_VTH.inc" "")))) ?session sess)
    maeSetSimOption("passive_compression_07" ?options list(list("temp" "27") list("tnom" "27") list("reltol" "1e-05") list("vabstol" "1e-9") list("iabstol" "1e-13") list("gmin" "1e-12") list("digits" "12")) ?session sess)
    testHandle=maeGetTestSession("passive_compression_07" ?session sess)
    asiSetHighPerformanceOptionVal(testHandle 'uniMode "Spectre")
    unless(equal(asiGetHighPerformanceOptionVal(testHandle 'uniMode) "Spectre") error("Cannot set ordinary Spectre engine.\n"))
    asiSetHighPerformanceOptionVal(testHandle 'errorLevel "Do not override")
    unless(maeSetAnalysis("passive_compression_07" "tran" ?enable t ?options list(list("stop" "2.5e-08") list("maxstep" "2e-12") list("strobeperiod" "5e-12") list("errpreset" "conservative")) ?session sess) error("Could not configure passive_compression_07/tran.\n"))
    maeAddOutput("rf" "passive_compression_07" ?outputType "net" ?signalName "/rf" ?save t ?plot nil ?session sess)
    maeAddOutput("rfdrive" "passive_compression_07" ?outputType "net" ?signalName "/rfdrive" ?save t ?plot nil ?session sess)
    maeAddOutput("outp" "passive_compression_07" ?outputType "net" ?signalName "/outp" ?save t ?plot nil ?session sess)
    maeAddOutput("outn" "passive_compression_07" ?outputType "net" ?signalName "/outn" ?save t ?plot nil ?session sess)
    maeAddOutput("lop" "passive_compression_07" ?outputType "net" ?signalName "/lop" ?save t ?plot nil ?session sess)
    maeAddOutput("lon" "passive_compression_07" ?outputType "net" ?signalName "/lon" ?save t ?plot nil ?session sess)
    unless(member("passive_compression_08" maeGetSetup(?session sess))
      maeCreateTest("passive_compression_08" ?lib "HW09_Mixers" ?cell "passive_tb" ?view "schematic" ?simulator "spectre" ?session sess))
    maeSetVar("pinDbm" "-16.25" ?typeName "test" ?typeValue list("passive_compression_08") ?session sess)
    maeSetVar("fRF" "5800000000.0" ?typeName "test" ?typeValue list("passive_compression_08") ?session sess)
    maeSetVar("fRF2" "5800000000.0" ?typeName "test" ?typeValue list("passive_compression_08") ?session sess)
    maeSetVar("tone2Scale" "0" ?typeName "test" ?typeValue list("passive_compression_08") ?session sess)
    maeSetVar("rfScale" "1" ?typeName "test" ?typeValue list("passive_compression_08") ?session sess)
    maeSetEnvOption("passive_compression_08" ?options list(list("modelFiles" list(list("/tools/designkits/NCSU/FreePDK4514/ncsu_basekit/models/hspice/tran_models/models_nom/NMOS_VTH.inc" "")))) ?session sess)
    maeSetSimOption("passive_compression_08" ?options list(list("temp" "27") list("tnom" "27") list("reltol" "1e-05") list("vabstol" "1e-9") list("iabstol" "1e-13") list("gmin" "1e-12") list("digits" "12")) ?session sess)
    testHandle=maeGetTestSession("passive_compression_08" ?session sess)
    asiSetHighPerformanceOptionVal(testHandle 'uniMode "Spectre")
    unless(equal(asiGetHighPerformanceOptionVal(testHandle 'uniMode) "Spectre") error("Cannot set ordinary Spectre engine.\n"))
    asiSetHighPerformanceOptionVal(testHandle 'errorLevel "Do not override")
    unless(maeSetAnalysis("passive_compression_08" "tran" ?enable t ?options list(list("stop" "2.5e-08") list("maxstep" "2e-12") list("strobeperiod" "5e-12") list("errpreset" "conservative")) ?session sess) error("Could not configure passive_compression_08/tran.\n"))
    maeAddOutput("rf" "passive_compression_08" ?outputType "net" ?signalName "/rf" ?save t ?plot nil ?session sess)
    maeAddOutput("rfdrive" "passive_compression_08" ?outputType "net" ?signalName "/rfdrive" ?save t ?plot nil ?session sess)
    maeAddOutput("outp" "passive_compression_08" ?outputType "net" ?signalName "/outp" ?save t ?plot nil ?session sess)
    maeAddOutput("outn" "passive_compression_08" ?outputType "net" ?signalName "/outn" ?save t ?plot nil ?session sess)
    maeAddOutput("lop" "passive_compression_08" ?outputType "net" ?signalName "/lop" ?save t ?plot nil ?session sess)
    maeAddOutput("lon" "passive_compression_08" ?outputType "net" ?signalName "/lon" ?save t ?plot nil ?session sess)
    unless(member("passive_compression_09" maeGetSetup(?session sess))
      maeCreateTest("passive_compression_09" ?lib "HW09_Mixers" ?cell "passive_tb" ?view "schematic" ?simulator "spectre" ?session sess))
    maeSetVar("pinDbm" "-15.625" ?typeName "test" ?typeValue list("passive_compression_09") ?session sess)
    maeSetVar("fRF" "5800000000.0" ?typeName "test" ?typeValue list("passive_compression_09") ?session sess)
    maeSetVar("fRF2" "5800000000.0" ?typeName "test" ?typeValue list("passive_compression_09") ?session sess)
    maeSetVar("tone2Scale" "0" ?typeName "test" ?typeValue list("passive_compression_09") ?session sess)
    maeSetVar("rfScale" "1" ?typeName "test" ?typeValue list("passive_compression_09") ?session sess)
    maeSetEnvOption("passive_compression_09" ?options list(list("modelFiles" list(list("/tools/designkits/NCSU/FreePDK4514/ncsu_basekit/models/hspice/tran_models/models_nom/NMOS_VTH.inc" "")))) ?session sess)
    maeSetSimOption("passive_compression_09" ?options list(list("temp" "27") list("tnom" "27") list("reltol" "1e-05") list("vabstol" "1e-9") list("iabstol" "1e-13") list("gmin" "1e-12") list("digits" "12")) ?session sess)
    testHandle=maeGetTestSession("passive_compression_09" ?session sess)
    asiSetHighPerformanceOptionVal(testHandle 'uniMode "Spectre")
    unless(equal(asiGetHighPerformanceOptionVal(testHandle 'uniMode) "Spectre") error("Cannot set ordinary Spectre engine.\n"))
    asiSetHighPerformanceOptionVal(testHandle 'errorLevel "Do not override")
    unless(maeSetAnalysis("passive_compression_09" "tran" ?enable t ?options list(list("stop" "2.5e-08") list("maxstep" "2e-12") list("strobeperiod" "5e-12") list("errpreset" "conservative")) ?session sess) error("Could not configure passive_compression_09/tran.\n"))
    maeAddOutput("rf" "passive_compression_09" ?outputType "net" ?signalName "/rf" ?save t ?plot nil ?session sess)
    maeAddOutput("rfdrive" "passive_compression_09" ?outputType "net" ?signalName "/rfdrive" ?save t ?plot nil ?session sess)
    maeAddOutput("outp" "passive_compression_09" ?outputType "net" ?signalName "/outp" ?save t ?plot nil ?session sess)
    maeAddOutput("outn" "passive_compression_09" ?outputType "net" ?signalName "/outn" ?save t ?plot nil ?session sess)
    maeAddOutput("lop" "passive_compression_09" ?outputType "net" ?signalName "/lop" ?save t ?plot nil ?session sess)
    maeAddOutput("lon" "passive_compression_09" ?outputType "net" ?signalName "/lon" ?save t ?plot nil ?session sess)
    unless(member("passive_compression_10" maeGetSetup(?session sess))
      maeCreateTest("passive_compression_10" ?lib "HW09_Mixers" ?cell "passive_tb" ?view "schematic" ?simulator "spectre" ?session sess))
    maeSetVar("pinDbm" "-15.46875" ?typeName "test" ?typeValue list("passive_compression_10") ?session sess)
    maeSetVar("fRF" "5800000000.0" ?typeName "test" ?typeValue list("passive_compression_10") ?session sess)
    maeSetVar("fRF2" "5800000000.0" ?typeName "test" ?typeValue list("passive_compression_10") ?session sess)
    maeSetVar("tone2Scale" "0" ?typeName "test" ?typeValue list("passive_compression_10") ?session sess)
    maeSetVar("rfScale" "1" ?typeName "test" ?typeValue list("passive_compression_10") ?session sess)
    maeSetEnvOption("passive_compression_10" ?options list(list("modelFiles" list(list("/tools/designkits/NCSU/FreePDK4514/ncsu_basekit/models/hspice/tran_models/models_nom/NMOS_VTH.inc" "")))) ?session sess)
    maeSetSimOption("passive_compression_10" ?options list(list("temp" "27") list("tnom" "27") list("reltol" "1e-05") list("vabstol" "1e-9") list("iabstol" "1e-13") list("gmin" "1e-12") list("digits" "12")) ?session sess)
    testHandle=maeGetTestSession("passive_compression_10" ?session sess)
    asiSetHighPerformanceOptionVal(testHandle 'uniMode "Spectre")
    unless(equal(asiGetHighPerformanceOptionVal(testHandle 'uniMode) "Spectre") error("Cannot set ordinary Spectre engine.\n"))
    asiSetHighPerformanceOptionVal(testHandle 'errorLevel "Do not override")
    unless(maeSetAnalysis("passive_compression_10" "tran" ?enable t ?options list(list("stop" "2.5e-08") list("maxstep" "2e-12") list("strobeperiod" "5e-12") list("errpreset" "conservative")) ?session sess) error("Could not configure passive_compression_10/tran.\n"))
    maeAddOutput("rf" "passive_compression_10" ?outputType "net" ?signalName "/rf" ?save t ?plot nil ?session sess)
    maeAddOutput("rfdrive" "passive_compression_10" ?outputType "net" ?signalName "/rfdrive" ?save t ?plot nil ?session sess)
    maeAddOutput("outp" "passive_compression_10" ?outputType "net" ?signalName "/outp" ?save t ?plot nil ?session sess)
    maeAddOutput("outn" "passive_compression_10" ?outputType "net" ?signalName "/outn" ?save t ?plot nil ?session sess)
    maeAddOutput("lop" "passive_compression_10" ?outputType "net" ?signalName "/lop" ?save t ?plot nil ?session sess)
    maeAddOutput("lon" "passive_compression_10" ?outputType "net" ?signalName "/lon" ?save t ?plot nil ?session sess)
    unless(member("passive_compression_11" maeGetSetup(?session sess))
      maeCreateTest("passive_compression_11" ?lib "HW09_Mixers" ?cell "passive_tb" ?view "schematic" ?simulator "spectre" ?session sess))
    maeSetVar("pinDbm" "-15.15625" ?typeName "test" ?typeValue list("passive_compression_11") ?session sess)
    maeSetVar("fRF" "5800000000.0" ?typeName "test" ?typeValue list("passive_compression_11") ?session sess)
    maeSetVar("fRF2" "5800000000.0" ?typeName "test" ?typeValue list("passive_compression_11") ?session sess)
    maeSetVar("tone2Scale" "0" ?typeName "test" ?typeValue list("passive_compression_11") ?session sess)
    maeSetVar("rfScale" "1" ?typeName "test" ?typeValue list("passive_compression_11") ?session sess)
    maeSetEnvOption("passive_compression_11" ?options list(list("modelFiles" list(list("/tools/designkits/NCSU/FreePDK4514/ncsu_basekit/models/hspice/tran_models/models_nom/NMOS_VTH.inc" "")))) ?session sess)
    maeSetSimOption("passive_compression_11" ?options list(list("temp" "27") list("tnom" "27") list("reltol" "1e-05") list("vabstol" "1e-9") list("iabstol" "1e-13") list("gmin" "1e-12") list("digits" "12")) ?session sess)
    testHandle=maeGetTestSession("passive_compression_11" ?session sess)
    asiSetHighPerformanceOptionVal(testHandle 'uniMode "Spectre")
    unless(equal(asiGetHighPerformanceOptionVal(testHandle 'uniMode) "Spectre") error("Cannot set ordinary Spectre engine.\n"))
    asiSetHighPerformanceOptionVal(testHandle 'errorLevel "Do not override")
    unless(maeSetAnalysis("passive_compression_11" "tran" ?enable t ?options list(list("stop" "2.5e-08") list("maxstep" "2e-12") list("strobeperiod" "5e-12") list("errpreset" "conservative")) ?session sess) error("Could not configure passive_compression_11/tran.\n"))
    maeAddOutput("rf" "passive_compression_11" ?outputType "net" ?signalName "/rf" ?save t ?plot nil ?session sess)
    maeAddOutput("rfdrive" "passive_compression_11" ?outputType "net" ?signalName "/rfdrive" ?save t ?plot nil ?session sess)
    maeAddOutput("outp" "passive_compression_11" ?outputType "net" ?signalName "/outp" ?save t ?plot nil ?session sess)
    maeAddOutput("outn" "passive_compression_11" ?outputType "net" ?signalName "/outn" ?save t ?plot nil ?session sess)
    maeAddOutput("lop" "passive_compression_11" ?outputType "net" ?signalName "/lop" ?save t ?plot nil ?session sess)
    maeAddOutput("lon" "passive_compression_11" ?outputType "net" ?signalName "/lon" ?save t ?plot nil ?session sess)
    unless(member("passive_compression_12" maeGetSetup(?session sess))
      maeCreateTest("passive_compression_12" ?lib "HW09_Mixers" ?cell "passive_tb" ?view "schematic" ?simulator "spectre" ?session sess))
    maeSetVar("pinDbm" "-15" ?typeName "test" ?typeValue list("passive_compression_12") ?session sess)
    maeSetVar("fRF" "5800000000.0" ?typeName "test" ?typeValue list("passive_compression_12") ?session sess)
    maeSetVar("fRF2" "5800000000.0" ?typeName "test" ?typeValue list("passive_compression_12") ?session sess)
    maeSetVar("tone2Scale" "0" ?typeName "test" ?typeValue list("passive_compression_12") ?session sess)
    maeSetVar("rfScale" "1" ?typeName "test" ?typeValue list("passive_compression_12") ?session sess)
    maeSetEnvOption("passive_compression_12" ?options list(list("modelFiles" list(list("/tools/designkits/NCSU/FreePDK4514/ncsu_basekit/models/hspice/tran_models/models_nom/NMOS_VTH.inc" "")))) ?session sess)
    maeSetSimOption("passive_compression_12" ?options list(list("temp" "27") list("tnom" "27") list("reltol" "1e-05") list("vabstol" "1e-9") list("iabstol" "1e-13") list("gmin" "1e-12") list("digits" "12")) ?session sess)
    testHandle=maeGetTestSession("passive_compression_12" ?session sess)
    asiSetHighPerformanceOptionVal(testHandle 'uniMode "Spectre")
    unless(equal(asiGetHighPerformanceOptionVal(testHandle 'uniMode) "Spectre") error("Cannot set ordinary Spectre engine.\n"))
    asiSetHighPerformanceOptionVal(testHandle 'errorLevel "Do not override")
    unless(maeSetAnalysis("passive_compression_12" "tran" ?enable t ?options list(list("stop" "2.5e-08") list("maxstep" "2e-12") list("strobeperiod" "5e-12") list("errpreset" "conservative")) ?session sess) error("Could not configure passive_compression_12/tran.\n"))
    maeAddOutput("rf" "passive_compression_12" ?outputType "net" ?signalName "/rf" ?save t ?plot nil ?session sess)
    maeAddOutput("rfdrive" "passive_compression_12" ?outputType "net" ?signalName "/rfdrive" ?save t ?plot nil ?session sess)
    maeAddOutput("outp" "passive_compression_12" ?outputType "net" ?signalName "/outp" ?save t ?plot nil ?session sess)
    maeAddOutput("outn" "passive_compression_12" ?outputType "net" ?signalName "/outn" ?save t ?plot nil ?session sess)
    maeAddOutput("lop" "passive_compression_12" ?outputType "net" ?signalName "/lop" ?save t ?plot nil ?session sess)
    maeAddOutput("lon" "passive_compression_12" ?outputType "net" ?signalName "/lon" ?save t ?plot nil ?session sess)
    unless(member("passive_compression_13" maeGetSetup(?session sess))
      maeCreateTest("passive_compression_13" ?lib "HW09_Mixers" ?cell "passive_tb" ?view "schematic" ?simulator "spectre" ?session sess))
    maeSetVar("pinDbm" "-10" ?typeName "test" ?typeValue list("passive_compression_13") ?session sess)
    maeSetVar("fRF" "5800000000.0" ?typeName "test" ?typeValue list("passive_compression_13") ?session sess)
    maeSetVar("fRF2" "5800000000.0" ?typeName "test" ?typeValue list("passive_compression_13") ?session sess)
    maeSetVar("tone2Scale" "0" ?typeName "test" ?typeValue list("passive_compression_13") ?session sess)
    maeSetVar("rfScale" "1" ?typeName "test" ?typeValue list("passive_compression_13") ?session sess)
    maeSetEnvOption("passive_compression_13" ?options list(list("modelFiles" list(list("/tools/designkits/NCSU/FreePDK4514/ncsu_basekit/models/hspice/tran_models/models_nom/NMOS_VTH.inc" "")))) ?session sess)
    maeSetSimOption("passive_compression_13" ?options list(list("temp" "27") list("tnom" "27") list("reltol" "1e-05") list("vabstol" "1e-9") list("iabstol" "1e-13") list("gmin" "1e-12") list("digits" "12")) ?session sess)
    testHandle=maeGetTestSession("passive_compression_13" ?session sess)
    asiSetHighPerformanceOptionVal(testHandle 'uniMode "Spectre")
    unless(equal(asiGetHighPerformanceOptionVal(testHandle 'uniMode) "Spectre") error("Cannot set ordinary Spectre engine.\n"))
    asiSetHighPerformanceOptionVal(testHandle 'errorLevel "Do not override")
    unless(maeSetAnalysis("passive_compression_13" "tran" ?enable t ?options list(list("stop" "2.5e-08") list("maxstep" "2e-12") list("strobeperiod" "5e-12") list("errpreset" "conservative")) ?session sess) error("Could not configure passive_compression_13/tran.\n"))
    maeAddOutput("rf" "passive_compression_13" ?outputType "net" ?signalName "/rf" ?save t ?plot nil ?session sess)
    maeAddOutput("rfdrive" "passive_compression_13" ?outputType "net" ?signalName "/rfdrive" ?save t ?plot nil ?session sess)
    maeAddOutput("outp" "passive_compression_13" ?outputType "net" ?signalName "/outp" ?save t ?plot nil ?session sess)
    maeAddOutput("outn" "passive_compression_13" ?outputType "net" ?signalName "/outn" ?save t ?plot nil ?session sess)
    maeAddOutput("lop" "passive_compression_13" ?outputType "net" ?signalName "/lop" ?save t ?plot nil ?session sess)
    maeAddOutput("lon" "passive_compression_13" ?outputType "net" ?signalName "/lon" ?save t ?plot nil ?session sess)
    unless(member("passive_two_tone_00" maeGetSetup(?session sess))
      maeCreateTest("passive_two_tone_00" ?lib "HW09_Mixers" ?cell "passive_tb" ?view "schematic" ?simulator "spectre" ?session sess))
    maeSetVar("pinDbm" "-50" ?typeName "test" ?typeValue list("passive_two_tone_00") ?session sess)
    maeSetVar("fRF" "5790000000.0" ?typeName "test" ?typeValue list("passive_two_tone_00") ?session sess)
    maeSetVar("fRF2" "5810000000.0" ?typeName "test" ?typeValue list("passive_two_tone_00") ?session sess)
    maeSetVar("tone2Scale" "1" ?typeName "test" ?typeValue list("passive_two_tone_00") ?session sess)
    maeSetVar("rfScale" "1" ?typeName "test" ?typeValue list("passive_two_tone_00") ?session sess)
    maeSetEnvOption("passive_two_tone_00" ?options list(list("modelFiles" list(list("/tools/designkits/NCSU/FreePDK4514/ncsu_basekit/models/hspice/tran_models/models_nom/NMOS_VTH.inc" "")))) ?session sess)
    maeSetSimOption("passive_two_tone_00" ?options list(list("temp" "27") list("tnom" "27") list("reltol" "1e-05") list("vabstol" "1e-9") list("iabstol" "1e-13") list("gmin" "1e-12") list("digits" "12")) ?session sess)
    testHandle=maeGetTestSession("passive_two_tone_00" ?session sess)
    asiSetHighPerformanceOptionVal(testHandle 'uniMode "Spectre")
    unless(equal(asiGetHighPerformanceOptionVal(testHandle 'uniMode) "Spectre") error("Cannot set ordinary Spectre engine.\n"))
    asiSetHighPerformanceOptionVal(testHandle 'errorLevel "Do not override")
    unless(maeSetAnalysis("passive_two_tone_00" "tran" ?enable t ?options list(list("stop" "1.2e-07") list("maxstep" "2e-12") list("strobeperiod" "5e-12") list("errpreset" "conservative")) ?session sess) error("Could not configure passive_two_tone_00/tran.\n"))
    maeAddOutput("rf" "passive_two_tone_00" ?outputType "net" ?signalName "/rf" ?save t ?plot nil ?session sess)
    maeAddOutput("rfdrive" "passive_two_tone_00" ?outputType "net" ?signalName "/rfdrive" ?save t ?plot nil ?session sess)
    maeAddOutput("outp" "passive_two_tone_00" ?outputType "net" ?signalName "/outp" ?save t ?plot nil ?session sess)
    maeAddOutput("outn" "passive_two_tone_00" ?outputType "net" ?signalName "/outn" ?save t ?plot nil ?session sess)
    maeAddOutput("lop" "passive_two_tone_00" ?outputType "net" ?signalName "/lop" ?save t ?plot nil ?session sess)
    maeAddOutput("lon" "passive_two_tone_00" ?outputType "net" ?signalName "/lon" ?save t ?plot nil ?session sess)
    unless(member("passive_two_tone_01" maeGetSetup(?session sess))
      maeCreateTest("passive_two_tone_01" ?lib "HW09_Mixers" ?cell "passive_tb" ?view "schematic" ?simulator "spectre" ?session sess))
    maeSetVar("pinDbm" "-45" ?typeName "test" ?typeValue list("passive_two_tone_01") ?session sess)
    maeSetVar("fRF" "5790000000.0" ?typeName "test" ?typeValue list("passive_two_tone_01") ?session sess)
    maeSetVar("fRF2" "5810000000.0" ?typeName "test" ?typeValue list("passive_two_tone_01") ?session sess)
    maeSetVar("tone2Scale" "1" ?typeName "test" ?typeValue list("passive_two_tone_01") ?session sess)
    maeSetVar("rfScale" "1" ?typeName "test" ?typeValue list("passive_two_tone_01") ?session sess)
    maeSetEnvOption("passive_two_tone_01" ?options list(list("modelFiles" list(list("/tools/designkits/NCSU/FreePDK4514/ncsu_basekit/models/hspice/tran_models/models_nom/NMOS_VTH.inc" "")))) ?session sess)
    maeSetSimOption("passive_two_tone_01" ?options list(list("temp" "27") list("tnom" "27") list("reltol" "1e-05") list("vabstol" "1e-9") list("iabstol" "1e-13") list("gmin" "1e-12") list("digits" "12")) ?session sess)
    testHandle=maeGetTestSession("passive_two_tone_01" ?session sess)
    asiSetHighPerformanceOptionVal(testHandle 'uniMode "Spectre")
    unless(equal(asiGetHighPerformanceOptionVal(testHandle 'uniMode) "Spectre") error("Cannot set ordinary Spectre engine.\n"))
    asiSetHighPerformanceOptionVal(testHandle 'errorLevel "Do not override")
    unless(maeSetAnalysis("passive_two_tone_01" "tran" ?enable t ?options list(list("stop" "1.2e-07") list("maxstep" "2e-12") list("strobeperiod" "5e-12") list("errpreset" "conservative")) ?session sess) error("Could not configure passive_two_tone_01/tran.\n"))
    maeAddOutput("rf" "passive_two_tone_01" ?outputType "net" ?signalName "/rf" ?save t ?plot nil ?session sess)
    maeAddOutput("rfdrive" "passive_two_tone_01" ?outputType "net" ?signalName "/rfdrive" ?save t ?plot nil ?session sess)
    maeAddOutput("outp" "passive_two_tone_01" ?outputType "net" ?signalName "/outp" ?save t ?plot nil ?session sess)
    maeAddOutput("outn" "passive_two_tone_01" ?outputType "net" ?signalName "/outn" ?save t ?plot nil ?session sess)
    maeAddOutput("lop" "passive_two_tone_01" ?outputType "net" ?signalName "/lop" ?save t ?plot nil ?session sess)
    maeAddOutput("lon" "passive_two_tone_01" ?outputType "net" ?signalName "/lon" ?save t ?plot nil ?session sess)
    unless(member("passive_two_tone_02" maeGetSetup(?session sess))
      maeCreateTest("passive_two_tone_02" ?lib "HW09_Mixers" ?cell "passive_tb" ?view "schematic" ?simulator "spectre" ?session sess))
    maeSetVar("pinDbm" "-40" ?typeName "test" ?typeValue list("passive_two_tone_02") ?session sess)
    maeSetVar("fRF" "5790000000.0" ?typeName "test" ?typeValue list("passive_two_tone_02") ?session sess)
    maeSetVar("fRF2" "5810000000.0" ?typeName "test" ?typeValue list("passive_two_tone_02") ?session sess)
    maeSetVar("tone2Scale" "1" ?typeName "test" ?typeValue list("passive_two_tone_02") ?session sess)
    maeSetVar("rfScale" "1" ?typeName "test" ?typeValue list("passive_two_tone_02") ?session sess)
    maeSetEnvOption("passive_two_tone_02" ?options list(list("modelFiles" list(list("/tools/designkits/NCSU/FreePDK4514/ncsu_basekit/models/hspice/tran_models/models_nom/NMOS_VTH.inc" "")))) ?session sess)
    maeSetSimOption("passive_two_tone_02" ?options list(list("temp" "27") list("tnom" "27") list("reltol" "1e-05") list("vabstol" "1e-9") list("iabstol" "1e-13") list("gmin" "1e-12") list("digits" "12")) ?session sess)
    testHandle=maeGetTestSession("passive_two_tone_02" ?session sess)
    asiSetHighPerformanceOptionVal(testHandle 'uniMode "Spectre")
    unless(equal(asiGetHighPerformanceOptionVal(testHandle 'uniMode) "Spectre") error("Cannot set ordinary Spectre engine.\n"))
    asiSetHighPerformanceOptionVal(testHandle 'errorLevel "Do not override")
    unless(maeSetAnalysis("passive_two_tone_02" "tran" ?enable t ?options list(list("stop" "1.2e-07") list("maxstep" "2e-12") list("strobeperiod" "5e-12") list("errpreset" "conservative")) ?session sess) error("Could not configure passive_two_tone_02/tran.\n"))
    maeAddOutput("rf" "passive_two_tone_02" ?outputType "net" ?signalName "/rf" ?save t ?plot nil ?session sess)
    maeAddOutput("rfdrive" "passive_two_tone_02" ?outputType "net" ?signalName "/rfdrive" ?save t ?plot nil ?session sess)
    maeAddOutput("outp" "passive_two_tone_02" ?outputType "net" ?signalName "/outp" ?save t ?plot nil ?session sess)
    maeAddOutput("outn" "passive_two_tone_02" ?outputType "net" ?signalName "/outn" ?save t ?plot nil ?session sess)
    maeAddOutput("lop" "passive_two_tone_02" ?outputType "net" ?signalName "/lop" ?save t ?plot nil ?session sess)
    maeAddOutput("lon" "passive_two_tone_02" ?outputType "net" ?signalName "/lon" ?save t ?plot nil ?session sess)
    unless(member("passive_two_tone_03" maeGetSetup(?session sess))
      maeCreateTest("passive_two_tone_03" ?lib "HW09_Mixers" ?cell "passive_tb" ?view "schematic" ?simulator "spectre" ?session sess))
    maeSetVar("pinDbm" "-35" ?typeName "test" ?typeValue list("passive_two_tone_03") ?session sess)
    maeSetVar("fRF" "5790000000.0" ?typeName "test" ?typeValue list("passive_two_tone_03") ?session sess)
    maeSetVar("fRF2" "5810000000.0" ?typeName "test" ?typeValue list("passive_two_tone_03") ?session sess)
    maeSetVar("tone2Scale" "1" ?typeName "test" ?typeValue list("passive_two_tone_03") ?session sess)
    maeSetVar("rfScale" "1" ?typeName "test" ?typeValue list("passive_two_tone_03") ?session sess)
    maeSetEnvOption("passive_two_tone_03" ?options list(list("modelFiles" list(list("/tools/designkits/NCSU/FreePDK4514/ncsu_basekit/models/hspice/tran_models/models_nom/NMOS_VTH.inc" "")))) ?session sess)
    maeSetSimOption("passive_two_tone_03" ?options list(list("temp" "27") list("tnom" "27") list("reltol" "1e-05") list("vabstol" "1e-9") list("iabstol" "1e-13") list("gmin" "1e-12") list("digits" "12")) ?session sess)
    testHandle=maeGetTestSession("passive_two_tone_03" ?session sess)
    asiSetHighPerformanceOptionVal(testHandle 'uniMode "Spectre")
    unless(equal(asiGetHighPerformanceOptionVal(testHandle 'uniMode) "Spectre") error("Cannot set ordinary Spectre engine.\n"))
    asiSetHighPerformanceOptionVal(testHandle 'errorLevel "Do not override")
    unless(maeSetAnalysis("passive_two_tone_03" "tran" ?enable t ?options list(list("stop" "1.2e-07") list("maxstep" "2e-12") list("strobeperiod" "5e-12") list("errpreset" "conservative")) ?session sess) error("Could not configure passive_two_tone_03/tran.\n"))
    maeAddOutput("rf" "passive_two_tone_03" ?outputType "net" ?signalName "/rf" ?save t ?plot nil ?session sess)
    maeAddOutput("rfdrive" "passive_two_tone_03" ?outputType "net" ?signalName "/rfdrive" ?save t ?plot nil ?session sess)
    maeAddOutput("outp" "passive_two_tone_03" ?outputType "net" ?signalName "/outp" ?save t ?plot nil ?session sess)
    maeAddOutput("outn" "passive_two_tone_03" ?outputType "net" ?signalName "/outn" ?save t ?plot nil ?session sess)
    maeAddOutput("lop" "passive_two_tone_03" ?outputType "net" ?signalName "/lop" ?save t ?plot nil ?session sess)
    maeAddOutput("lon" "passive_two_tone_03" ?outputType "net" ?signalName "/lon" ?save t ?plot nil ?session sess)
    unless(member("passive_two_tone_04" maeGetSetup(?session sess))
      maeCreateTest("passive_two_tone_04" ?lib "HW09_Mixers" ?cell "passive_tb" ?view "schematic" ?simulator "spectre" ?session sess))
    maeSetVar("pinDbm" "-30" ?typeName "test" ?typeValue list("passive_two_tone_04") ?session sess)
    maeSetVar("fRF" "5790000000.0" ?typeName "test" ?typeValue list("passive_two_tone_04") ?session sess)
    maeSetVar("fRF2" "5810000000.0" ?typeName "test" ?typeValue list("passive_two_tone_04") ?session sess)
    maeSetVar("tone2Scale" "1" ?typeName "test" ?typeValue list("passive_two_tone_04") ?session sess)
    maeSetVar("rfScale" "1" ?typeName "test" ?typeValue list("passive_two_tone_04") ?session sess)
    maeSetEnvOption("passive_two_tone_04" ?options list(list("modelFiles" list(list("/tools/designkits/NCSU/FreePDK4514/ncsu_basekit/models/hspice/tran_models/models_nom/NMOS_VTH.inc" "")))) ?session sess)
    maeSetSimOption("passive_two_tone_04" ?options list(list("temp" "27") list("tnom" "27") list("reltol" "1e-05") list("vabstol" "1e-9") list("iabstol" "1e-13") list("gmin" "1e-12") list("digits" "12")) ?session sess)
    testHandle=maeGetTestSession("passive_two_tone_04" ?session sess)
    asiSetHighPerformanceOptionVal(testHandle 'uniMode "Spectre")
    unless(equal(asiGetHighPerformanceOptionVal(testHandle 'uniMode) "Spectre") error("Cannot set ordinary Spectre engine.\n"))
    asiSetHighPerformanceOptionVal(testHandle 'errorLevel "Do not override")
    unless(maeSetAnalysis("passive_two_tone_04" "tran" ?enable t ?options list(list("stop" "1.2e-07") list("maxstep" "2e-12") list("strobeperiod" "5e-12") list("errpreset" "conservative")) ?session sess) error("Could not configure passive_two_tone_04/tran.\n"))
    maeAddOutput("rf" "passive_two_tone_04" ?outputType "net" ?signalName "/rf" ?save t ?plot nil ?session sess)
    maeAddOutput("rfdrive" "passive_two_tone_04" ?outputType "net" ?signalName "/rfdrive" ?save t ?plot nil ?session sess)
    maeAddOutput("outp" "passive_two_tone_04" ?outputType "net" ?signalName "/outp" ?save t ?plot nil ?session sess)
    maeAddOutput("outn" "passive_two_tone_04" ?outputType "net" ?signalName "/outn" ?save t ?plot nil ?session sess)
    maeAddOutput("lop" "passive_two_tone_04" ?outputType "net" ?signalName "/lop" ?save t ?plot nil ?session sess)
    maeAddOutput("lon" "passive_two_tone_04" ?outputType "net" ?signalName "/lon" ?save t ?plot nil ?session sess)
    unless(member("passive_two_tone_05" maeGetSetup(?session sess))
      maeCreateTest("passive_two_tone_05" ?lib "HW09_Mixers" ?cell "passive_tb" ?view "schematic" ?simulator "spectre" ?session sess))
    maeSetVar("pinDbm" "-25" ?typeName "test" ?typeValue list("passive_two_tone_05") ?session sess)
    maeSetVar("fRF" "5790000000.0" ?typeName "test" ?typeValue list("passive_two_tone_05") ?session sess)
    maeSetVar("fRF2" "5810000000.0" ?typeName "test" ?typeValue list("passive_two_tone_05") ?session sess)
    maeSetVar("tone2Scale" "1" ?typeName "test" ?typeValue list("passive_two_tone_05") ?session sess)
    maeSetVar("rfScale" "1" ?typeName "test" ?typeValue list("passive_two_tone_05") ?session sess)
    maeSetEnvOption("passive_two_tone_05" ?options list(list("modelFiles" list(list("/tools/designkits/NCSU/FreePDK4514/ncsu_basekit/models/hspice/tran_models/models_nom/NMOS_VTH.inc" "")))) ?session sess)
    maeSetSimOption("passive_two_tone_05" ?options list(list("temp" "27") list("tnom" "27") list("reltol" "1e-05") list("vabstol" "1e-9") list("iabstol" "1e-13") list("gmin" "1e-12") list("digits" "12")) ?session sess)
    testHandle=maeGetTestSession("passive_two_tone_05" ?session sess)
    asiSetHighPerformanceOptionVal(testHandle 'uniMode "Spectre")
    unless(equal(asiGetHighPerformanceOptionVal(testHandle 'uniMode) "Spectre") error("Cannot set ordinary Spectre engine.\n"))
    asiSetHighPerformanceOptionVal(testHandle 'errorLevel "Do not override")
    unless(maeSetAnalysis("passive_two_tone_05" "tran" ?enable t ?options list(list("stop" "1.2e-07") list("maxstep" "2e-12") list("strobeperiod" "5e-12") list("errpreset" "conservative")) ?session sess) error("Could not configure passive_two_tone_05/tran.\n"))
    maeAddOutput("rf" "passive_two_tone_05" ?outputType "net" ?signalName "/rf" ?save t ?plot nil ?session sess)
    maeAddOutput("rfdrive" "passive_two_tone_05" ?outputType "net" ?signalName "/rfdrive" ?save t ?plot nil ?session sess)
    maeAddOutput("outp" "passive_two_tone_05" ?outputType "net" ?signalName "/outp" ?save t ?plot nil ?session sess)
    maeAddOutput("outn" "passive_two_tone_05" ?outputType "net" ?signalName "/outn" ?save t ?plot nil ?session sess)
    maeAddOutput("lop" "passive_two_tone_05" ?outputType "net" ?signalName "/lop" ?save t ?plot nil ?session sess)
    maeAddOutput("lon" "passive_two_tone_05" ?outputType "net" ?signalName "/lon" ?save t ?plot nil ?session sess)
    unless(member("passive_two_tone_06" maeGetSetup(?session sess))
      maeCreateTest("passive_two_tone_06" ?lib "HW09_Mixers" ?cell "passive_tb" ?view "schematic" ?simulator "spectre" ?session sess))
    maeSetVar("pinDbm" "-20" ?typeName "test" ?typeValue list("passive_two_tone_06") ?session sess)
    maeSetVar("fRF" "5790000000.0" ?typeName "test" ?typeValue list("passive_two_tone_06") ?session sess)
    maeSetVar("fRF2" "5810000000.0" ?typeName "test" ?typeValue list("passive_two_tone_06") ?session sess)
    maeSetVar("tone2Scale" "1" ?typeName "test" ?typeValue list("passive_two_tone_06") ?session sess)
    maeSetVar("rfScale" "1" ?typeName "test" ?typeValue list("passive_two_tone_06") ?session sess)
    maeSetEnvOption("passive_two_tone_06" ?options list(list("modelFiles" list(list("/tools/designkits/NCSU/FreePDK4514/ncsu_basekit/models/hspice/tran_models/models_nom/NMOS_VTH.inc" "")))) ?session sess)
    maeSetSimOption("passive_two_tone_06" ?options list(list("temp" "27") list("tnom" "27") list("reltol" "1e-05") list("vabstol" "1e-9") list("iabstol" "1e-13") list("gmin" "1e-12") list("digits" "12")) ?session sess)
    testHandle=maeGetTestSession("passive_two_tone_06" ?session sess)
    asiSetHighPerformanceOptionVal(testHandle 'uniMode "Spectre")
    unless(equal(asiGetHighPerformanceOptionVal(testHandle 'uniMode) "Spectre") error("Cannot set ordinary Spectre engine.\n"))
    asiSetHighPerformanceOptionVal(testHandle 'errorLevel "Do not override")
    unless(maeSetAnalysis("passive_two_tone_06" "tran" ?enable t ?options list(list("stop" "1.2e-07") list("maxstep" "2e-12") list("strobeperiod" "5e-12") list("errpreset" "conservative")) ?session sess) error("Could not configure passive_two_tone_06/tran.\n"))
    maeAddOutput("rf" "passive_two_tone_06" ?outputType "net" ?signalName "/rf" ?save t ?plot nil ?session sess)
    maeAddOutput("rfdrive" "passive_two_tone_06" ?outputType "net" ?signalName "/rfdrive" ?save t ?plot nil ?session sess)
    maeAddOutput("outp" "passive_two_tone_06" ?outputType "net" ?signalName "/outp" ?save t ?plot nil ?session sess)
    maeAddOutput("outn" "passive_two_tone_06" ?outputType "net" ?signalName "/outn" ?save t ?plot nil ?session sess)
    maeAddOutput("lop" "passive_two_tone_06" ?outputType "net" ?signalName "/lop" ?save t ?plot nil ?session sess)
    maeAddOutput("lon" "passive_two_tone_06" ?outputType "net" ?signalName "/lon" ?save t ?plot nil ?session sess)
    unless(member("passive_two_tone_tight" maeGetSetup(?session sess))
      maeCreateTest("passive_two_tone_tight" ?lib "HW09_Mixers" ?cell "passive_tb" ?view "schematic" ?simulator "spectre" ?session sess))
    maeSetVar("pinDbm" "-35" ?typeName "test" ?typeValue list("passive_two_tone_tight") ?session sess)
    maeSetVar("fRF" "5790000000.0" ?typeName "test" ?typeValue list("passive_two_tone_tight") ?session sess)
    maeSetVar("fRF2" "5810000000.0" ?typeName "test" ?typeValue list("passive_two_tone_tight") ?session sess)
    maeSetVar("tone2Scale" "1" ?typeName "test" ?typeValue list("passive_two_tone_tight") ?session sess)
    maeSetVar("rfScale" "1" ?typeName "test" ?typeValue list("passive_two_tone_tight") ?session sess)
    maeSetEnvOption("passive_two_tone_tight" ?options list(list("modelFiles" list(list("/tools/designkits/NCSU/FreePDK4514/ncsu_basekit/models/hspice/tran_models/models_nom/NMOS_VTH.inc" "")))) ?session sess)
    maeSetSimOption("passive_two_tone_tight" ?options list(list("temp" "27") list("tnom" "27") list("reltol" "1e-06") list("vabstol" "1e-9") list("iabstol" "1e-13") list("gmin" "1e-12") list("digits" "12")) ?session sess)
    testHandle=maeGetTestSession("passive_two_tone_tight" ?session sess)
    asiSetHighPerformanceOptionVal(testHandle 'uniMode "Spectre")
    unless(equal(asiGetHighPerformanceOptionVal(testHandle 'uniMode) "Spectre") error("Cannot set ordinary Spectre engine.\n"))
    asiSetHighPerformanceOptionVal(testHandle 'errorLevel "Do not override")
    unless(maeSetAnalysis("passive_two_tone_tight" "tran" ?enable t ?options list(list("stop" "1.2e-07") list("maxstep" "1e-12") list("strobeperiod" "5e-12") list("errpreset" "conservative")) ?session sess) error("Could not configure passive_two_tone_tight/tran.\n"))
    maeAddOutput("rf" "passive_two_tone_tight" ?outputType "net" ?signalName "/rf" ?save t ?plot nil ?session sess)
    maeAddOutput("rfdrive" "passive_two_tone_tight" ?outputType "net" ?signalName "/rfdrive" ?save t ?plot nil ?session sess)
    maeAddOutput("outp" "passive_two_tone_tight" ?outputType "net" ?signalName "/outp" ?save t ?plot nil ?session sess)
    maeAddOutput("outn" "passive_two_tone_tight" ?outputType "net" ?signalName "/outn" ?save t ?plot nil ?session sess)
    maeAddOutput("lop" "passive_two_tone_tight" ?outputType "net" ?signalName "/lop" ?save t ?plot nil ?session sess)
    maeAddOutput("lon" "passive_two_tone_tight" ?outputType "net" ?signalName "/lon" ?save t ?plot nil ?session sess)
    unless(member("active_noise_sb15" maeGetSetup(?session sess))
      maeCreateTest("active_noise_sb15" ?lib "HW09_Mixers" ?cell "active_tb" ?view "schematic" ?simulator "spectre" ?session sess))
    maeSetVar("pinDbm" "-55" ?typeName "test" ?typeValue list("active_noise_sb15") ?session sess)
    maeSetVar("fRF" "5800000000.0" ?typeName "test" ?typeValue list("active_noise_sb15") ?session sess)
    maeSetVar("fRF2" "5800000000.0" ?typeName "test" ?typeValue list("active_noise_sb15") ?session sess)
    maeSetVar("rfScale" "0" ?typeName "test" ?typeValue list("active_noise_sb15") ?session sess)
    maeSetVar("tone2Scale" "0" ?typeName "test" ?typeValue list("active_noise_sb15") ?session sess)
    maeSetEnvOption("active_noise_sb15" ?options list(list("modelFiles" list(list("/tools/designkits/NCSU/FreePDK4514/ncsu_basekit/models/hspice/tran_models/models_nom/NMOS_VTH.inc" "")))) ?session sess)
    maeSetSimOption("active_noise_sb15" ?options list(list("temp" "27") list("tnom" "27") list("reltol" "1e-05") list("vabstol" "1e-9") list("iabstol" "1e-13") list("gmin" "1e-12") list("digits" "12")) ?session sess)
    testHandle=maeGetTestSession("active_noise_sb15" ?session sess)
    asiSetHighPerformanceOptionVal(testHandle 'uniMode "Spectre")
    unless(equal(asiGetHighPerformanceOptionVal(testHandle 'uniMode) "Spectre") error("Cannot set ordinary Spectre engine.\n"))
    asiSetHighPerformanceOptionVal(testHandle 'errorLevel "Do not override")
    unless(maeSetAnalysis("active_noise_sb15" "pss" ?enable t ?options list(list("engine" "Shooting") list("fund" "5.6G") list("harms" "63") list("tstab" "5n") list("errpreset" "conservative") list("method" "gear2only") list("maxacfreq" "381.348G")) ?session sess) error("Could not configure active_noise_sb15/pss.\n"))
    unless(maeSetAnalysis("active_noise_sb15" "pac" ?enable t ?options list(list("sweeptype" "absolute") list("rangeType" "Start-Stop") list("start" "5.7G") list("stop" "5.9G") list("incrType" "Linear") list("stepTypeLin" "Step Size") list("step" "100M") list("maxsideband" "1") list("freqaxis" "in")) ?session sess) error("Could not configure active_noise_sb15/pac.\n"))
    unless(maeSetAnalysis("active_noise_sb15" "pnoise" ?enable t ?options list(list("sweeptype" "absolute") list("rangeType" "Start-Stop") list("start" "100M") list("stop" "300M") list("incrType" "Linear") list("stepTypeLin" "Step Size") list("step" "100M") list("maxsideband" "15") list("noiseFigure" t) list("outType" "voltage") list("p" "/outp") list("n" "/outn") list("inType" "port") list("inPort" "/RFPORT") list("iprobe" "/RFPORT") list("refsideband" "1") list("noisetype" "timeaverage")) ?session sess) error("Could not configure active_noise_sb15/pnoise.\n"))
    maeAddOutput("rf" "active_noise_sb15" ?outputType "net" ?signalName "/rf" ?save t ?plot nil ?session sess)
    maeAddOutput("rfdrive" "active_noise_sb15" ?outputType "net" ?signalName "/rfdrive" ?save t ?plot nil ?session sess)
    maeAddOutput("outp" "active_noise_sb15" ?outputType "net" ?signalName "/outp" ?save t ?plot nil ?session sess)
    maeAddOutput("outn" "active_noise_sb15" ?outputType "net" ?signalName "/outn" ?save t ?plot nil ?session sess)
    maeAddOutput("lop" "active_noise_sb15" ?outputType "net" ?signalName "/lop" ?save t ?plot nil ?session sess)
    maeAddOutput("lon" "active_noise_sb15" ?outputType "net" ?signalName "/lon" ?save t ?plot nil ?session sess)
    maeAddOutput("tail" "active_noise_sb15" ?outputType "net" ?signalName "/tail" ?save t ?plot nil ?session sess)
    maeAddOutput("vdd_current" "active_noise_sb15" ?outputType "terminal" ?signalName "/VDD/PLUS" ?save t ?plot nil ?session sess)
    unless(member("active_noise_sb31" maeGetSetup(?session sess))
      maeCreateTest("active_noise_sb31" ?lib "HW09_Mixers" ?cell "active_tb" ?view "schematic" ?simulator "spectre" ?session sess))
    maeSetVar("pinDbm" "-55" ?typeName "test" ?typeValue list("active_noise_sb31") ?session sess)
    maeSetVar("fRF" "5800000000.0" ?typeName "test" ?typeValue list("active_noise_sb31") ?session sess)
    maeSetVar("fRF2" "5800000000.0" ?typeName "test" ?typeValue list("active_noise_sb31") ?session sess)
    maeSetVar("rfScale" "0" ?typeName "test" ?typeValue list("active_noise_sb31") ?session sess)
    maeSetVar("tone2Scale" "0" ?typeName "test" ?typeValue list("active_noise_sb31") ?session sess)
    maeSetEnvOption("active_noise_sb31" ?options list(list("modelFiles" list(list("/tools/designkits/NCSU/FreePDK4514/ncsu_basekit/models/hspice/tran_models/models_nom/NMOS_VTH.inc" "")))) ?session sess)
    maeSetSimOption("active_noise_sb31" ?options list(list("temp" "27") list("tnom" "27") list("reltol" "1e-05") list("vabstol" "1e-9") list("iabstol" "1e-13") list("gmin" "1e-12") list("digits" "12")) ?session sess)
    testHandle=maeGetTestSession("active_noise_sb31" ?session sess)
    asiSetHighPerformanceOptionVal(testHandle 'uniMode "Spectre")
    unless(equal(asiGetHighPerformanceOptionVal(testHandle 'uniMode) "Spectre") error("Cannot set ordinary Spectre engine.\n"))
    asiSetHighPerformanceOptionVal(testHandle 'errorLevel "Do not override")
    unless(maeSetAnalysis("active_noise_sb31" "pss" ?enable t ?options list(list("engine" "Shooting") list("fund" "5.6G") list("harms" "63") list("tstab" "5n") list("errpreset" "conservative") list("method" "gear2only") list("maxacfreq" "381.348G")) ?session sess) error("Could not configure active_noise_sb31/pss.\n"))
    unless(maeSetAnalysis("active_noise_sb31" "pac" ?enable t ?options list(list("sweeptype" "absolute") list("rangeType" "Start-Stop") list("start" "5.7G") list("stop" "5.9G") list("incrType" "Linear") list("stepTypeLin" "Step Size") list("step" "100M") list("maxsideband" "1") list("freqaxis" "in")) ?session sess) error("Could not configure active_noise_sb31/pac.\n"))
    unless(maeSetAnalysis("active_noise_sb31" "pnoise" ?enable t ?options list(list("sweeptype" "absolute") list("rangeType" "Start-Stop") list("start" "100M") list("stop" "300M") list("incrType" "Linear") list("stepTypeLin" "Step Size") list("step" "100M") list("maxsideband" "31") list("noiseFigure" t) list("outType" "voltage") list("p" "/outp") list("n" "/outn") list("inType" "port") list("inPort" "/RFPORT") list("iprobe" "/RFPORT") list("refsideband" "1") list("noisetype" "timeaverage")) ?session sess) error("Could not configure active_noise_sb31/pnoise.\n"))
    maeAddOutput("rf" "active_noise_sb31" ?outputType "net" ?signalName "/rf" ?save t ?plot nil ?session sess)
    maeAddOutput("rfdrive" "active_noise_sb31" ?outputType "net" ?signalName "/rfdrive" ?save t ?plot nil ?session sess)
    maeAddOutput("outp" "active_noise_sb31" ?outputType "net" ?signalName "/outp" ?save t ?plot nil ?session sess)
    maeAddOutput("outn" "active_noise_sb31" ?outputType "net" ?signalName "/outn" ?save t ?plot nil ?session sess)
    maeAddOutput("lop" "active_noise_sb31" ?outputType "net" ?signalName "/lop" ?save t ?plot nil ?session sess)
    maeAddOutput("lon" "active_noise_sb31" ?outputType "net" ?signalName "/lon" ?save t ?plot nil ?session sess)
    maeAddOutput("tail" "active_noise_sb31" ?outputType "net" ?signalName "/tail" ?save t ?plot nil ?session sess)
    maeAddOutput("vdd_current" "active_noise_sb31" ?outputType "terminal" ?signalName "/VDD/PLUS" ?save t ?plot nil ?session sess)
    unless(member("active_noise_sb63" maeGetSetup(?session sess))
      maeCreateTest("active_noise_sb63" ?lib "HW09_Mixers" ?cell "active_tb" ?view "schematic" ?simulator "spectre" ?session sess))
    maeSetVar("pinDbm" "-55" ?typeName "test" ?typeValue list("active_noise_sb63") ?session sess)
    maeSetVar("fRF" "5800000000.0" ?typeName "test" ?typeValue list("active_noise_sb63") ?session sess)
    maeSetVar("fRF2" "5800000000.0" ?typeName "test" ?typeValue list("active_noise_sb63") ?session sess)
    maeSetVar("rfScale" "0" ?typeName "test" ?typeValue list("active_noise_sb63") ?session sess)
    maeSetVar("tone2Scale" "0" ?typeName "test" ?typeValue list("active_noise_sb63") ?session sess)
    maeSetEnvOption("active_noise_sb63" ?options list(list("modelFiles" list(list("/tools/designkits/NCSU/FreePDK4514/ncsu_basekit/models/hspice/tran_models/models_nom/NMOS_VTH.inc" "")))) ?session sess)
    maeSetSimOption("active_noise_sb63" ?options list(list("temp" "27") list("tnom" "27") list("reltol" "1e-05") list("vabstol" "1e-9") list("iabstol" "1e-13") list("gmin" "1e-12") list("digits" "12")) ?session sess)
    testHandle=maeGetTestSession("active_noise_sb63" ?session sess)
    asiSetHighPerformanceOptionVal(testHandle 'uniMode "Spectre")
    unless(equal(asiGetHighPerformanceOptionVal(testHandle 'uniMode) "Spectre") error("Cannot set ordinary Spectre engine.\n"))
    asiSetHighPerformanceOptionVal(testHandle 'errorLevel "Do not override")
    unless(maeSetAnalysis("active_noise_sb63" "pss" ?enable t ?options list(list("engine" "Shooting") list("fund" "5.6G") list("harms" "63") list("tstab" "5n") list("errpreset" "conservative") list("method" "gear2only") list("maxacfreq" "381.348G")) ?session sess) error("Could not configure active_noise_sb63/pss.\n"))
    unless(maeSetAnalysis("active_noise_sb63" "pac" ?enable t ?options list(list("sweeptype" "absolute") list("rangeType" "Start-Stop") list("start" "5.7G") list("stop" "5.9G") list("incrType" "Linear") list("stepTypeLin" "Step Size") list("step" "100M") list("maxsideband" "1") list("freqaxis" "in")) ?session sess) error("Could not configure active_noise_sb63/pac.\n"))
    unless(maeSetAnalysis("active_noise_sb63" "pnoise" ?enable t ?options list(list("sweeptype" "absolute") list("rangeType" "Start-Stop") list("start" "100M") list("stop" "300M") list("incrType" "Linear") list("stepTypeLin" "Step Size") list("step" "100M") list("maxsideband" "63") list("noiseFigure" t) list("outType" "voltage") list("p" "/outp") list("n" "/outn") list("inType" "port") list("inPort" "/RFPORT") list("iprobe" "/RFPORT") list("refsideband" "1") list("noisetype" "timeaverage")) ?session sess) error("Could not configure active_noise_sb63/pnoise.\n"))
    maeAddOutput("rf" "active_noise_sb63" ?outputType "net" ?signalName "/rf" ?save t ?plot nil ?session sess)
    maeAddOutput("rfdrive" "active_noise_sb63" ?outputType "net" ?signalName "/rfdrive" ?save t ?plot nil ?session sess)
    maeAddOutput("outp" "active_noise_sb63" ?outputType "net" ?signalName "/outp" ?save t ?plot nil ?session sess)
    maeAddOutput("outn" "active_noise_sb63" ?outputType "net" ?signalName "/outn" ?save t ?plot nil ?session sess)
    maeAddOutput("lop" "active_noise_sb63" ?outputType "net" ?signalName "/lop" ?save t ?plot nil ?session sess)
    maeAddOutput("lon" "active_noise_sb63" ?outputType "net" ?signalName "/lon" ?save t ?plot nil ?session sess)
    maeAddOutput("tail" "active_noise_sb63" ?outputType "net" ?signalName "/tail" ?save t ?plot nil ?session sess)
    maeAddOutput("vdd_current" "active_noise_sb63" ?outputType "terminal" ?signalName "/VDD/PLUS" ?save t ?plot nil ?session sess)
    unless(member("active_noise_image" maeGetSetup(?session sess))
      maeCreateTest("active_noise_image" ?lib "HW09_Mixers" ?cell "active_tb" ?view "schematic" ?simulator "spectre" ?session sess))
    maeSetVar("pinDbm" "-55" ?typeName "test" ?typeValue list("active_noise_image") ?session sess)
    maeSetVar("fRF" "5800000000.0" ?typeName "test" ?typeValue list("active_noise_image") ?session sess)
    maeSetVar("fRF2" "5800000000.0" ?typeName "test" ?typeValue list("active_noise_image") ?session sess)
    maeSetVar("rfScale" "0" ?typeName "test" ?typeValue list("active_noise_image") ?session sess)
    maeSetVar("tone2Scale" "0" ?typeName "test" ?typeValue list("active_noise_image") ?session sess)
    maeSetEnvOption("active_noise_image" ?options list(list("modelFiles" list(list("/tools/designkits/NCSU/FreePDK4514/ncsu_basekit/models/hspice/tran_models/models_nom/NMOS_VTH.inc" "")))) ?session sess)
    maeSetSimOption("active_noise_image" ?options list(list("temp" "27") list("tnom" "27") list("reltol" "1e-05") list("vabstol" "1e-9") list("iabstol" "1e-13") list("gmin" "1e-12") list("digits" "12")) ?session sess)
    testHandle=maeGetTestSession("active_noise_image" ?session sess)
    asiSetHighPerformanceOptionVal(testHandle 'uniMode "Spectre")
    unless(equal(asiGetHighPerformanceOptionVal(testHandle 'uniMode) "Spectre") error("Cannot set ordinary Spectre engine.\n"))
    asiSetHighPerformanceOptionVal(testHandle 'errorLevel "Do not override")
    unless(maeSetAnalysis("active_noise_image" "pss" ?enable t ?options list(list("engine" "Shooting") list("fund" "5.6G") list("harms" "63") list("tstab" "5n") list("errpreset" "conservative") list("method" "gear2only") list("maxacfreq" "381.348G")) ?session sess) error("Could not configure active_noise_image/pss.\n"))
    unless(maeSetAnalysis("active_noise_image" "pac" ?enable t ?options list(list("sweeptype" "absolute") list("rangeType" "Start-Stop") list("start" "5.3G") list("stop" "5.5G") list("incrType" "Linear") list("stepTypeLin" "Step Size") list("step" "100M") list("maxsideband" "1") list("freqaxis" "in")) ?session sess) error("Could not configure active_noise_image/pac.\n"))
    maeAddOutput("rf" "active_noise_image" ?outputType "net" ?signalName "/rf" ?save t ?plot nil ?session sess)
    maeAddOutput("rfdrive" "active_noise_image" ?outputType "net" ?signalName "/rfdrive" ?save t ?plot nil ?session sess)
    maeAddOutput("outp" "active_noise_image" ?outputType "net" ?signalName "/outp" ?save t ?plot nil ?session sess)
    maeAddOutput("outn" "active_noise_image" ?outputType "net" ?signalName "/outn" ?save t ?plot nil ?session sess)
    maeAddOutput("lop" "active_noise_image" ?outputType "net" ?signalName "/lop" ?save t ?plot nil ?session sess)
    maeAddOutput("lon" "active_noise_image" ?outputType "net" ?signalName "/lon" ?save t ?plot nil ?session sess)
    maeAddOutput("tail" "active_noise_image" ?outputType "net" ?signalName "/tail" ?save t ?plot nil ?session sess)
    maeAddOutput("vdd_current" "active_noise_image" ?outputType "terminal" ?signalName "/VDD/PLUS" ?save t ?plot nil ?session sess)
    unless(member("passive_noise_sb15" maeGetSetup(?session sess))
      maeCreateTest("passive_noise_sb15" ?lib "HW09_Mixers" ?cell "passive_tb" ?view "schematic" ?simulator "spectre" ?session sess))
    maeSetVar("pinDbm" "-55" ?typeName "test" ?typeValue list("passive_noise_sb15") ?session sess)
    maeSetVar("fRF" "5800000000.0" ?typeName "test" ?typeValue list("passive_noise_sb15") ?session sess)
    maeSetVar("fRF2" "5800000000.0" ?typeName "test" ?typeValue list("passive_noise_sb15") ?session sess)
    maeSetVar("rfScale" "0" ?typeName "test" ?typeValue list("passive_noise_sb15") ?session sess)
    maeSetVar("tone2Scale" "0" ?typeName "test" ?typeValue list("passive_noise_sb15") ?session sess)
    maeSetEnvOption("passive_noise_sb15" ?options list(list("modelFiles" list(list("/tools/designkits/NCSU/FreePDK4514/ncsu_basekit/models/hspice/tran_models/models_nom/NMOS_VTH.inc" "")))) ?session sess)
    maeSetSimOption("passive_noise_sb15" ?options list(list("temp" "27") list("tnom" "27") list("reltol" "1e-05") list("vabstol" "1e-9") list("iabstol" "1e-13") list("gmin" "1e-12") list("digits" "12")) ?session sess)
    testHandle=maeGetTestSession("passive_noise_sb15" ?session sess)
    asiSetHighPerformanceOptionVal(testHandle 'uniMode "Spectre")
    unless(equal(asiGetHighPerformanceOptionVal(testHandle 'uniMode) "Spectre") error("Cannot set ordinary Spectre engine.\n"))
    asiSetHighPerformanceOptionVal(testHandle 'errorLevel "Do not override")
    unless(maeSetAnalysis("passive_noise_sb15" "pss" ?enable t ?options list(list("engine" "Shooting") list("fund" "5.6G") list("harms" "63") list("tstab" "5n") list("errpreset" "conservative") list("method" "gear2only") list("maxacfreq" "381.348G")) ?session sess) error("Could not configure passive_noise_sb15/pss.\n"))
    unless(maeSetAnalysis("passive_noise_sb15" "pac" ?enable t ?options list(list("sweeptype" "absolute") list("rangeType" "Start-Stop") list("start" "5.7G") list("stop" "5.9G") list("incrType" "Linear") list("stepTypeLin" "Step Size") list("step" "100M") list("maxsideband" "1") list("freqaxis" "in")) ?session sess) error("Could not configure passive_noise_sb15/pac.\n"))
    unless(maeSetAnalysis("passive_noise_sb15" "pnoise" ?enable t ?options list(list("sweeptype" "absolute") list("rangeType" "Start-Stop") list("start" "100M") list("stop" "300M") list("incrType" "Linear") list("stepTypeLin" "Step Size") list("step" "100M") list("maxsideband" "15") list("noiseFigure" t) list("outType" "voltage") list("p" "/outp") list("n" "/outn") list("inType" "port") list("inPort" "/RFPORT") list("iprobe" "/RFPORT") list("refsideband" "1") list("noisetype" "timeaverage")) ?session sess) error("Could not configure passive_noise_sb15/pnoise.\n"))
    maeAddOutput("rf" "passive_noise_sb15" ?outputType "net" ?signalName "/rf" ?save t ?plot nil ?session sess)
    maeAddOutput("rfdrive" "passive_noise_sb15" ?outputType "net" ?signalName "/rfdrive" ?save t ?plot nil ?session sess)
    maeAddOutput("outp" "passive_noise_sb15" ?outputType "net" ?signalName "/outp" ?save t ?plot nil ?session sess)
    maeAddOutput("outn" "passive_noise_sb15" ?outputType "net" ?signalName "/outn" ?save t ?plot nil ?session sess)
    maeAddOutput("lop" "passive_noise_sb15" ?outputType "net" ?signalName "/lop" ?save t ?plot nil ?session sess)
    maeAddOutput("lon" "passive_noise_sb15" ?outputType "net" ?signalName "/lon" ?save t ?plot nil ?session sess)
    unless(member("passive_noise_sb31" maeGetSetup(?session sess))
      maeCreateTest("passive_noise_sb31" ?lib "HW09_Mixers" ?cell "passive_tb" ?view "schematic" ?simulator "spectre" ?session sess))
    maeSetVar("pinDbm" "-55" ?typeName "test" ?typeValue list("passive_noise_sb31") ?session sess)
    maeSetVar("fRF" "5800000000.0" ?typeName "test" ?typeValue list("passive_noise_sb31") ?session sess)
    maeSetVar("fRF2" "5800000000.0" ?typeName "test" ?typeValue list("passive_noise_sb31") ?session sess)
    maeSetVar("rfScale" "0" ?typeName "test" ?typeValue list("passive_noise_sb31") ?session sess)
    maeSetVar("tone2Scale" "0" ?typeName "test" ?typeValue list("passive_noise_sb31") ?session sess)
    maeSetEnvOption("passive_noise_sb31" ?options list(list("modelFiles" list(list("/tools/designkits/NCSU/FreePDK4514/ncsu_basekit/models/hspice/tran_models/models_nom/NMOS_VTH.inc" "")))) ?session sess)
    maeSetSimOption("passive_noise_sb31" ?options list(list("temp" "27") list("tnom" "27") list("reltol" "1e-05") list("vabstol" "1e-9") list("iabstol" "1e-13") list("gmin" "1e-12") list("digits" "12")) ?session sess)
    testHandle=maeGetTestSession("passive_noise_sb31" ?session sess)
    asiSetHighPerformanceOptionVal(testHandle 'uniMode "Spectre")
    unless(equal(asiGetHighPerformanceOptionVal(testHandle 'uniMode) "Spectre") error("Cannot set ordinary Spectre engine.\n"))
    asiSetHighPerformanceOptionVal(testHandle 'errorLevel "Do not override")
    unless(maeSetAnalysis("passive_noise_sb31" "pss" ?enable t ?options list(list("engine" "Shooting") list("fund" "5.6G") list("harms" "63") list("tstab" "5n") list("errpreset" "conservative") list("method" "gear2only") list("maxacfreq" "381.348G")) ?session sess) error("Could not configure passive_noise_sb31/pss.\n"))
    unless(maeSetAnalysis("passive_noise_sb31" "pac" ?enable t ?options list(list("sweeptype" "absolute") list("rangeType" "Start-Stop") list("start" "5.7G") list("stop" "5.9G") list("incrType" "Linear") list("stepTypeLin" "Step Size") list("step" "100M") list("maxsideband" "1") list("freqaxis" "in")) ?session sess) error("Could not configure passive_noise_sb31/pac.\n"))
    unless(maeSetAnalysis("passive_noise_sb31" "pnoise" ?enable t ?options list(list("sweeptype" "absolute") list("rangeType" "Start-Stop") list("start" "100M") list("stop" "300M") list("incrType" "Linear") list("stepTypeLin" "Step Size") list("step" "100M") list("maxsideband" "31") list("noiseFigure" t) list("outType" "voltage") list("p" "/outp") list("n" "/outn") list("inType" "port") list("inPort" "/RFPORT") list("iprobe" "/RFPORT") list("refsideband" "1") list("noisetype" "timeaverage")) ?session sess) error("Could not configure passive_noise_sb31/pnoise.\n"))
    maeAddOutput("rf" "passive_noise_sb31" ?outputType "net" ?signalName "/rf" ?save t ?plot nil ?session sess)
    maeAddOutput("rfdrive" "passive_noise_sb31" ?outputType "net" ?signalName "/rfdrive" ?save t ?plot nil ?session sess)
    maeAddOutput("outp" "passive_noise_sb31" ?outputType "net" ?signalName "/outp" ?save t ?plot nil ?session sess)
    maeAddOutput("outn" "passive_noise_sb31" ?outputType "net" ?signalName "/outn" ?save t ?plot nil ?session sess)
    maeAddOutput("lop" "passive_noise_sb31" ?outputType "net" ?signalName "/lop" ?save t ?plot nil ?session sess)
    maeAddOutput("lon" "passive_noise_sb31" ?outputType "net" ?signalName "/lon" ?save t ?plot nil ?session sess)
    unless(member("passive_noise_sb63" maeGetSetup(?session sess))
      maeCreateTest("passive_noise_sb63" ?lib "HW09_Mixers" ?cell "passive_tb" ?view "schematic" ?simulator "spectre" ?session sess))
    maeSetVar("pinDbm" "-55" ?typeName "test" ?typeValue list("passive_noise_sb63") ?session sess)
    maeSetVar("fRF" "5800000000.0" ?typeName "test" ?typeValue list("passive_noise_sb63") ?session sess)
    maeSetVar("fRF2" "5800000000.0" ?typeName "test" ?typeValue list("passive_noise_sb63") ?session sess)
    maeSetVar("rfScale" "0" ?typeName "test" ?typeValue list("passive_noise_sb63") ?session sess)
    maeSetVar("tone2Scale" "0" ?typeName "test" ?typeValue list("passive_noise_sb63") ?session sess)
    maeSetEnvOption("passive_noise_sb63" ?options list(list("modelFiles" list(list("/tools/designkits/NCSU/FreePDK4514/ncsu_basekit/models/hspice/tran_models/models_nom/NMOS_VTH.inc" "")))) ?session sess)
    maeSetSimOption("passive_noise_sb63" ?options list(list("temp" "27") list("tnom" "27") list("reltol" "1e-05") list("vabstol" "1e-9") list("iabstol" "1e-13") list("gmin" "1e-12") list("digits" "12")) ?session sess)
    testHandle=maeGetTestSession("passive_noise_sb63" ?session sess)
    asiSetHighPerformanceOptionVal(testHandle 'uniMode "Spectre")
    unless(equal(asiGetHighPerformanceOptionVal(testHandle 'uniMode) "Spectre") error("Cannot set ordinary Spectre engine.\n"))
    asiSetHighPerformanceOptionVal(testHandle 'errorLevel "Do not override")
    unless(maeSetAnalysis("passive_noise_sb63" "pss" ?enable t ?options list(list("engine" "Shooting") list("fund" "5.6G") list("harms" "63") list("tstab" "5n") list("errpreset" "conservative") list("method" "gear2only") list("maxacfreq" "381.348G")) ?session sess) error("Could not configure passive_noise_sb63/pss.\n"))
    unless(maeSetAnalysis("passive_noise_sb63" "pac" ?enable t ?options list(list("sweeptype" "absolute") list("rangeType" "Start-Stop") list("start" "5.7G") list("stop" "5.9G") list("incrType" "Linear") list("stepTypeLin" "Step Size") list("step" "100M") list("maxsideband" "1") list("freqaxis" "in")) ?session sess) error("Could not configure passive_noise_sb63/pac.\n"))
    unless(maeSetAnalysis("passive_noise_sb63" "pnoise" ?enable t ?options list(list("sweeptype" "absolute") list("rangeType" "Start-Stop") list("start" "100M") list("stop" "300M") list("incrType" "Linear") list("stepTypeLin" "Step Size") list("step" "100M") list("maxsideband" "63") list("noiseFigure" t) list("outType" "voltage") list("p" "/outp") list("n" "/outn") list("inType" "port") list("inPort" "/RFPORT") list("iprobe" "/RFPORT") list("refsideband" "1") list("noisetype" "timeaverage")) ?session sess) error("Could not configure passive_noise_sb63/pnoise.\n"))
    maeAddOutput("rf" "passive_noise_sb63" ?outputType "net" ?signalName "/rf" ?save t ?plot nil ?session sess)
    maeAddOutput("rfdrive" "passive_noise_sb63" ?outputType "net" ?signalName "/rfdrive" ?save t ?plot nil ?session sess)
    maeAddOutput("outp" "passive_noise_sb63" ?outputType "net" ?signalName "/outp" ?save t ?plot nil ?session sess)
    maeAddOutput("outn" "passive_noise_sb63" ?outputType "net" ?signalName "/outn" ?save t ?plot nil ?session sess)
    maeAddOutput("lop" "passive_noise_sb63" ?outputType "net" ?signalName "/lop" ?save t ?plot nil ?session sess)
    maeAddOutput("lon" "passive_noise_sb63" ?outputType "net" ?signalName "/lon" ?save t ?plot nil ?session sess)
    unless(member("passive_noise_image" maeGetSetup(?session sess))
      maeCreateTest("passive_noise_image" ?lib "HW09_Mixers" ?cell "passive_tb" ?view "schematic" ?simulator "spectre" ?session sess))
    maeSetVar("pinDbm" "-55" ?typeName "test" ?typeValue list("passive_noise_image") ?session sess)
    maeSetVar("fRF" "5800000000.0" ?typeName "test" ?typeValue list("passive_noise_image") ?session sess)
    maeSetVar("fRF2" "5800000000.0" ?typeName "test" ?typeValue list("passive_noise_image") ?session sess)
    maeSetVar("rfScale" "0" ?typeName "test" ?typeValue list("passive_noise_image") ?session sess)
    maeSetVar("tone2Scale" "0" ?typeName "test" ?typeValue list("passive_noise_image") ?session sess)
    maeSetEnvOption("passive_noise_image" ?options list(list("modelFiles" list(list("/tools/designkits/NCSU/FreePDK4514/ncsu_basekit/models/hspice/tran_models/models_nom/NMOS_VTH.inc" "")))) ?session sess)
    maeSetSimOption("passive_noise_image" ?options list(list("temp" "27") list("tnom" "27") list("reltol" "1e-05") list("vabstol" "1e-9") list("iabstol" "1e-13") list("gmin" "1e-12") list("digits" "12")) ?session sess)
    testHandle=maeGetTestSession("passive_noise_image" ?session sess)
    asiSetHighPerformanceOptionVal(testHandle 'uniMode "Spectre")
    unless(equal(asiGetHighPerformanceOptionVal(testHandle 'uniMode) "Spectre") error("Cannot set ordinary Spectre engine.\n"))
    asiSetHighPerformanceOptionVal(testHandle 'errorLevel "Do not override")
    unless(maeSetAnalysis("passive_noise_image" "pss" ?enable t ?options list(list("engine" "Shooting") list("fund" "5.6G") list("harms" "63") list("tstab" "5n") list("errpreset" "conservative") list("method" "gear2only") list("maxacfreq" "381.348G")) ?session sess) error("Could not configure passive_noise_image/pss.\n"))
    unless(maeSetAnalysis("passive_noise_image" "pac" ?enable t ?options list(list("sweeptype" "absolute") list("rangeType" "Start-Stop") list("start" "5.3G") list("stop" "5.5G") list("incrType" "Linear") list("stepTypeLin" "Step Size") list("step" "100M") list("maxsideband" "1") list("freqaxis" "in")) ?session sess) error("Could not configure passive_noise_image/pac.\n"))
    maeAddOutput("rf" "passive_noise_image" ?outputType "net" ?signalName "/rf" ?save t ?plot nil ?session sess)
    maeAddOutput("rfdrive" "passive_noise_image" ?outputType "net" ?signalName "/rfdrive" ?save t ?plot nil ?session sess)
    maeAddOutput("outp" "passive_noise_image" ?outputType "net" ?signalName "/outp" ?save t ?plot nil ?session sess)
    maeAddOutput("outn" "passive_noise_image" ?outputType "net" ?signalName "/outn" ?save t ?plot nil ?session sess)
    maeAddOutput("lop" "passive_noise_image" ?outputType "net" ?signalName "/lop" ?save t ?plot nil ?session sess)
    maeAddOutput("lon" "passive_noise_image" ?outputType "net" ?signalName "/lon" ?save t ?plot nil ?session sess)
    maeEnableTests(?all t ?enable nil ?session sess)
    maeEnableTests(?testNames list("active_single_tone" "passive_single_tone") ?enable t ?session sess)
    when(member("active_probe" maeGetSetup(?session sess)) maeEnableTests(?testNames list("active_probe") ?enable nil ?session sess))
    maeSaveSetup(?session sess)
    out=outfile("/nethome/sjeon84/Gatech-ECE6420/HW09/ade_setup_audit.txt")
    fprintf(out "SESSION %L\nTESTS %L\nPOLICY %L\n" sess maeGetSetup(?session sess) maeGetJobPolicy(?session sess))
    foreach(testName maeGetSetup(?session sess)
      fprintf(out "TEST %s TRAN %L\nPSS %L\nPAC %L\nPNOISE %L\nSIMULATOR %L\nENVIRONMENT %L\n" testName maeGetAnalysis(testName "tran" ?session sess) maeGetAnalysis(testName "pss" ?session sess) maeGetAnalysis(testName "pac" ?session sess) maeGetAnalysis(testName "pnoise" ?session sess) maeGetSimOption(testName ?session sess) maeGetEnvOption(testName ?session sess))
    )
    testHandle=maeGetTestSession("active_noise_sb63" ?session sess)
    foreach(fieldName list('outType 'inType 'sweeptype)
      fprintf(out "PNOISE_FIELD_CHOICES %L %L\n" fieldName asiGetAnalysisFieldChoices(asiGetAnalysis(testHandle 'pnoise) fieldName))
    )
    close(out)
    printf("HW09 native ADE setup saved. Use GUI Run All to start Spectre.\n")
    windowNumber=axlGetSessionWindowNumber(sess)
    if(and(numberp(windowNumber) windowNumber>0) then
      hiRaiseWindow(windowNumber t)
    else
      maeSaveSetup(?session sess)
      maeCloseSession(?session sess ?forceClose nil)
      guiWindow=deOpenCellView("HW09_Mixers" "mixer_campaign" "maestro" "" nil "a")
      when(guiWindow errset(hiRaiseWindow(guiWindow) t))
    )
    sess
  )
)
hw09ConfigureADE()
