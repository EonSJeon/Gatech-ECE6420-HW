; Native dark-mode export of existing GUI graphs and saved schematics.
; No simulation, PSF reload, numerical reevaluation, or electrical edit.
procedure(hw09NightRestoreCIW()
  let((ci)
    ci=hiGetCIWindow()
    when(ci
      hiResizeWindow(ci list(list(10 760) list(1590 980)))
      hiRaiseWindow(ci)))
  0.0
)
procedure(hw09NightSchematic(kind destination receipt proof)
  let((win cv before after file saved)
    win=if(equal(kind "active") then hw09PresentationActiveWindow else hw09PresentationPassiveWindow)
    cv=geGetEditCellView(win)
    unless(cv && equal(cv~>libName "HW09_Mixers") && equal(cv~>cellName strcat(kind "_tb"))
      error("Expected existing HW09 schematic window: %s\n" kind))
    before=hw09PresentationElectrical(cv)
    fprintf(proof "before\t%s\t%L\n" kind before)
    hiRaiseWindow(win)
    file=strcat(destination "/" kind "_gui_testbench.png")
    saved=hiExportImage(?fileName file ?window win ?exportRegion 'entireDesign
      ?width 3600 ?keepAspect t ?colorType 'fullColor ?verbose t)
    unless(saved && isFile(file) error("Native dark schematic export failed: %s\n" file))
    after=hw09PresentationElectrical(cv)
    fprintf(proof "after\t%s\t%L\n" kind after)
    unless(equal(before after) error("Electrical state changed during native export.\n"))
    fprintf(proof "unchanged\t%s\tt\n" kind)
    fprintf(receipt "export\t%s\ttestbench\tcadence_gui_export\thiExportImage\t%s\t%L\t%L\n"
      kind file getCurrentTime() win)
    drain(receipt) drain(proof)
  )
)

procedure(hw09ExportPlots()
  let((receipt file saved stamp)
    unless(length(hw09PlotWindows)==12 error("Inspect all twelve native plot windows before export.\n"))
    receipt=outfile(strcat(hw09PlotOutput "/native_export_receipt.tsv") "w")
    unless(receipt error("Cannot write native export receipt.\n"))
    fprintf(receipt "SOURCE_RUN\t%s\n" hw09PlotSourceRun)
    foreach(row hw09PlotWindows
      vvSetGraphBackground("black" nth(2 row))
      awvSetCurrentWindow(nth(2 row))
      hiRaiseWindow(awvGetHiWindow(nth(2 row)))
      file=strcat(hw09PlotOutput "/" car(row) "_" cadr(row) ".png")
      stamp=getCurrentTime()
      saved=saveGraphImage(?window nth(2 row) ?fileName file
        ?width 2400 ?height 1600 ?units "pixels" ?backgroundColor "black"
        ?enableTitle t ?enableLegend t ?enableAxes t ?enableGrids t
        ?saveAllSubwindows t ?saveEachSubwindowSeparately nil)
      unless(and(saved isFile(file)) error("Native graph export failed: %s\n" file))
      fprintf(receipt "EXPORT\t%s\t%L\t%s\t%s\t%s\t%s\n"
        stamp nth(2 row) car(row) cadr(row) file nth(3 row))
      foreach(source nth(4 row)
        fprintf(receipt "SOURCE\t%s\t%s\t%s\n" car(row) cadr(row) hw09Psf(source)))
      printf("HW09 native visible ViVA export written: %s\n" file)
    )
    close(receipt)
    when(hw09PlotAudit close(hw09PlotAudit) hw09PlotAudit=nil)
    printf("HW09 twelve actual ViVA graph PNG files and native export receipt complete.\n")
  )
)

procedure(hw09NightExportAll()
  let((receipt proof)
    hw09ExportPlots()
    receipt=outfile(strcat(hw09PlotRoot "/cadence/presentation_exports.tsv") "w")
    proof=outfile(strcat(hw09PlotRoot "/cadence/presentation_night_electrical.tsv") "w")
    foreach(kind list("active" "passive") hw09NightSchematic(kind strcat(hw09PlotRoot "/cadence") receipt proof))
    close(receipt) close(proof)
    printf("HW09 DARK EXPORT COMPLETE: twelve ViVA plots and two full-color native schematics.\n")
  )
)
procedure(hw09NightExportProtected()
  errset(hw09NightExportAll() t)
  hw09NightRestoreCIW()
  hiRegTimer("hw09NightRestoreCIW()" 10)
  0.0
)
hiRegTimer("hw09NightExportProtected()" 10)
