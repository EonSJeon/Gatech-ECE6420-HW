; Expose the existing native ADE matrix in the task's no-WM FastX desktop.
; Window 8 and window 11 are task-owned SKILL editors confirmed by the operator.
procedure(hw09FocusADEGUI()
  let((sess windowNumber out name)
    foreach(existing maeGetSessions()
      when(and(equal(axlGetSessionLibName(existing) "HW09_Mixers")
               equal(axlGetSessionCellName(existing) "mixer_campaign")) sess=existing)
    )
    unless(sess error("No graphical HW09 ADE session is open.\n"))
    windowNumber=axlGetSessionWindowNumber(sess)
    out=outfile("/nethome/sjeon84/Gatech-ECE6420/HW09/gui_window_audit.txt")
    fprintf(out "SESSION %L GUI_WINDOW_NUMBER %L\n" sess windowNumber)
    foreach(w hiGetWindowList('all)
      name=hiGetWindowName(w)
      fprintf(out "WINDOW %L NAME %L\n" w name)
      when(and(stringp(name) rexMatchp("guifocus.il" name)) errset(hiUnmapWindow(w) t))
    )
    close(out)
    errset(hiUnmapWindow(window(8)) t)
    errset(hiUnmapWindow(window(11)) t)
    printf("HW09 GUI session %L: raising actual ADE window number %L.\n" sess windowNumber)
    when(and(numberp(windowNumber) windowNumber>0) hiRaiseWindow(windowNumber t))
  )
)
hw09FocusADEGUI()
; Repeat after the source-loader focus callback finishes.
hiRegTimer("hw09FocusADEGUI()" 5)
