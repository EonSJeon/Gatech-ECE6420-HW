; Read native ADE field names before configuring a schematic-based campaign.
procedure(hw09ADEProbe()
  let((sess testHandle out jp)
    envSetVal("asimenv.startup" "projectDir" 'string "/nethome/sjeon84/Gatech-ECE6420/HW09/simulation/cadence_gui")
    envSetVal("adexl.results" "saveDir" 'string "/nethome/sjeon84/Gatech-ECE6420/HW09/simulation/cadence_gui")
    envSetVal("adexl.results" "saveResDir" 'string "/nethome/sjeon84/Gatech-ECE6420/HW09/simulation/cadence_gui")
    envSetVal("spectre.outputs" "simOutputFormat" 'string "psf")
    sess=maeOpenSetup("HW09_Mixers" "mixer_campaign" "maestro" ?application "Assembler")
    unless(sess error("Could not create HW09 maestro setup.\n"))
    maeCreateTest("active_probe" ?lib "HW09_Mixers" ?cell "active_tb" ?view "schematic" ?simulator "spectre" ?session sess)
    testHandle=maeGetTestSession("active_probe" ?session sess)
    out=outfile("/nethome/sjeon84/Gatech-ECE6420/HW09/ade_probe.txt")
    fprintf(out "SESSION %L\n" sess)
    foreach(ana '("tran" "pss" "pac" "pnoise")
      fprintf(out "ANALYSIS %s %L\n" ana maeGetAnalysis("active_probe" ana ?includeEmpty t ?session sess))
    )
    fprintf(out "ENVIRONMENT %L\n" maeGetEnvOption("active_probe" ?includeEmpty t ?session sess))
    fprintf(out "SIMULATOR %L\n" maeGetSimOption("active_probe" ?includeEmpty t ?session sess))
    fprintf(out "JOBPOLICY %L\n" maeGetJobPolicy(?session sess))
    fprintf(out "SESSIONHANDLE %L\n" testHandle)
    close(out)
    maeSaveSetup(?session sess)
    printf("HW09 ADE metadata written to ade_probe.txt; no simulation requested.\n")
    sess
  )
)
hw09ADEProbe()
