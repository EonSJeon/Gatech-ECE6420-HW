; Export native ADE history paths after the visible GUI run has completed.
; This file never invokes a simulator or reuses standalone Spectre netlists.
procedure(hw09ExportADEPaths()
  let((sess hid out psf netlist)
    sess=maeOpenSetup("HW09_Mixers" "mixer_campaign" "maestro" ?application "Assembler")
    unless(sess error("HW09 native ADE session is not open.\n"))
    hid=axlGetCurrentHistory(sess)
    unless(hid error("No GUI simulation history exists to export.\n"))
    out=outfile("/nethome/sjeon84/Gatech-ECE6420/HW09/ade_native_paths.tsv")
    fprintf(out "history_handle\ttest_name\tpsf_directory\tnetlist_directory\n")
    foreach(testName maeGetSetup(?session sess)
      psf=axlGetPointPsfDir(hid testName)
      netlist=axlGetPointNetlistDir(hid testName)
      fprintf(out "%L\t%L\t%L\t%L\n" hid testName psf netlist)
    )
    close(out)
    maeSaveSetup(?session sess)
    printf("Native ADE history paths exported to ade_native_paths.tsv.\n")
    hid
  )
)
hw09ExportADEPaths()
