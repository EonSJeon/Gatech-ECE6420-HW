; Display/export of existing native graphs only. No data reload or reevaluation.
envSetVal("viva.axis" "font" 'string "Open Sans,20,-1,5,50,0,0,0,0,0")
envSetVal("viva.graph" "titleFont" 'string "Open Sans,22,-1,5,63,0,0,0,0,0")
envSetVal("viva.graph" "subTitleFont" 'string "Open Sans,20,-1,5,50,0,0,0,0,0")
envSetVal("viva.traceLegend" "font" 'string "Open Sans,20,-1,5,50,0,0,0,0,0")
envSetVal("viva.traceLegend" "printSaveImageFont" 'string "Open Sans,20,-1,5,50,0,0,0,0,0")
foreach(row hw09PlotWindows
  let((win role bounds step)
    win=nth(2 row) role=cadr(row)
    foreach(sub awvGetSubwindowList(win ?all t)
      awvSetCurrentWindow(win)
      awvSetCurrentSubwindow(win sub)
      awvSetLegendPos(win "above" ?subwindow sub)
      cond(
        (equal(role "transient")
          bounds=if(sub==1 then list(22.9e-9 25.3e-9) else list(4.5e-9 25.5e-9))
          step=if(sub==1 then 0.5e-9 else 5.0e-9))
        (equal(role "spectrum")
          bounds=if(sub==1 then list(0.0 12.4e9) else list(0.0 850.0e6))
          step=if(sub==1 then 2.0e9 else 200.0e6))
        (equal(role "twotone_spectrum")
          bounds=list(110.0e6 290.0e6) step=20.0e6)
        (equal(role "compression")
          bounds=list(-62.0 -8.0) step=10.0)
        (equal(role "iip3")
          bounds=list(-52.0 -18.0) step=10.0)
        (equal(role "noise")
          bounds=list(90.0e6 310.0e6) step=50.0e6)
      )
      xLimit(bounds)
      awvSetXAxisUseStepValue(win t ?subwindow sub)
      awvSetXAxisStepValue(win step ?subwindow sub)
    )
  )
)
procedure(hw09ResizePreviewRestoreCIW()
  let((ci)
    ci=hiGetCIWindow()
    when(ci
      hiResizeWindow(ci list(list(10 760) list(1590 980)))
      hiRaiseWindow(ci))
  )
  0.0
)
procedure(hw09ResizePreviewImages()
  let((directory win actual file saved)
    directory=strcat(hw09PlotRoot "/cadence/gui_exports/resize_preview_v1")
    unless(isDir(directory) createDir(directory))
    foreach(role list("iip3" "transient")
      win=nil
      foreach(row hw09PlotWindows
        when(and(equal(car(row) "active") equal(cadr(row) role)) win=nth(2 row)))
      unless(win error("Missing existing active native graph.\n"))
      awvSetCurrentWindow(win)
      actual=awvGetHiWindow(win)
      when(actual hiRaiseWindow(actual))
      file=strcat(directory "/active_" role ".png")
      saved=saveGraphImage(?window win ?fileName file
        ?width 2400 ?height 1600 ?units "pixels" ?backgroundColor "white"
        ?enableTitle t ?enableLegend t ?enableAxes t ?enableGrids t
        ?saveAllSubwindows t ?saveEachSubwindowSeparately nil)
      unless(and(saved isFile(file)) error("Native resized preview failed: %s\n" file))
      printf("HW09 native above-legend resized preview written: %s\n" file)
    )
  )
)
procedure(hw09ResizePreviewProtected()
  let((status)
    status=errset(hw09ResizePreviewImages() t)
    hw09ResizePreviewRestoreCIW()
    hiRegTimer("hw09ResizePreviewRestoreCIW()" 10)
    unless(status printf("HW09 preview failed; CIW focus restored for inspection.\n"))
  )
  0.0
)
hiRegTimer("hw09ResizePreviewProtected()" 10)
