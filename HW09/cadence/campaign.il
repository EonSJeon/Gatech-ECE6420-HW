; Enable the prepared native tests; never start a simulation automatically.
let((sess windowNumber)
  foreach(existing maeGetSessions()
    when(and(equal(axlGetSessionLibName(existing) "HW09_Mixers")
             equal(axlGetSessionCellName(existing) "mixer_campaign")) sess=existing)
  )
  unless(sess error("Open the native HW09 maestro GUI before enabling tests.\n"))
  maeEnableTests(?all t ?enable t ?session sess)
  when(member("active_probe" maeGetSetup(?session sess))
    maeEnableTests(?testNames list("active_probe") ?enable nil ?session sess)
  )
  maeSaveSetup(?session sess)
  printf("Prepared native campaign tests are enabled. Start Run All in the GUI.\n")
  windowNumber=axlGetSessionWindowNumber(sess)
  printf("HW09 enabled session %L actual ADE GUI window %L.\n" sess windowNumber)
  when(and(numberp(windowNumber) windowNumber>0) hiRaiseWindow(windowNumber t))
)
