; Display/export of existing native graphs only. No data reload or reevaluation.
envSetVal("viva.axis" "font" 'string "Open Sans,20,-1,5,50,0,0,0,0,0")
envSetVal("viva.graph" "titleFont" 'string "Open Sans,22,-1,5,63,0,0,0,0,0")
envSetVal("viva.graph" "subTitleFont" 'string "Open Sans,20,-1,5,50,0,0,0,0,0")
envSetVal("viva.traceLegend" "font" 'string "Open Sans,20,-1,5,50,0,0,0,0,0")
envSetVal("viva.traceLegend" "printSaveImageFont" 'string "Open Sans,20,-1,5,50,0,0,0,0,0")
foreach(row hw09PlotWindows
  let((win role bounds step)
    win=nth(2 row) role=cadr(row)
    foreach(sub awvGetSubwindowList(win ?all t)
      awvSetCurrentWindow(win)
      awvSetCurrentSubwindow(win sub)
      awvSetLegendPos(win "above" ?subwindow sub)
      cond(
        (equal(role "transient")
          bounds=if(sub==1 then list(22.9e-9 25.3e-9) else list(4.5e-9 25.5e-9))
          step=if(sub==1 then 0.5e-9 else 5.0e-9))
        (equal(role "spectrum")
          bounds=if(sub==1 then list(0.0 12.4e9) else list(0.0 850.0e6))
          step=if(sub==1 then 2.0e9 else 200.0e6))
        (equal(role "twotone_spectrum")
          bounds=list(110.0e6 300.0e6) step=20.0e6)
        (equal(role "compression")
          bounds=list(-62.0 -8.0) step=10.0)
        (equal(role "iip3")
          bounds=list(-52.0 -18.0) step=10.0)
        (equal(role "noise")
          bounds=list(90.0e6 310.0e6) step=50.0e6)
      )
      xLimit(bounds)
      awvSetXAxisUseStepValue(win t ?subwindow sub)
      awvSetXAxisStepValue(win step ?subwindow sub)
    )
  )
)
printf("HW09 approved native above-legends, fixed tick steps, and display margins applied; data unchanged.\n")
