; Finalize/query an existing native ADE session without opening a duplicate.
; All plots stay disabled and simulation must be started in the GUI.
procedure(hw09ADEFindSession()
  let((sess)
    foreach(existing maeGetSessions()
      when(and(equal(axlGetSessionLibName(existing) "HW09_Mixers")
               equal(axlGetSessionCellName(existing) "mixer_campaign"))
        sess=existing
      )
    )
    unless(sess error("No open HW09 native ADE session was found.\n"))
    sess
  )
)
procedure(hw09ADEFinalize()
  let((sess jp out controls th windowNumber guiWindow)
    sess=hw09ADEFindSession()
    foreach(testName list("active_single_tone" "passive_single_tone" "active_noise_sb63" "passive_noise_sb63" "active_noise_image" "passive_noise_image")
      unless(member(testName maeGetSetup(?session sess)) error("Required test %s is missing. Finish native setup before running.\n" testName))
    )
    jp=maeGetJobPolicy(?session sess)
    jp->distributionmethod="Local"
    jp->maxjobs="2"
    jp->preemptivestart="0"
    maeSetJobPolicy(jp ?session sess)
    maeEnableTests(?all t ?enable nil ?session sess)
    maeEnableTests(?testNames list("active_single_tone" "passive_single_tone") ?enable t ?session sess)
    maeSaveSetup(?session sess)
    out=outfile("/nethome/sjeon84/Gatech-ECE6420/HW09/ade_final_audit.txt")
    controls=outfile("/nethome/sjeon84/Gatech-ECE6420/HW09/ade_controls_probe.scs")
    fprintf(out "SESSION %L\nTESTS %L\nENABLED %L\nJOBPOLICY %L\n" sess maeGetSetup(?session sess) maeGetSetup(?enabled t ?session sess) maeGetJobPolicy(?session sess))
    foreach(testName list("active_single_tone" "passive_single_tone")
      th=maeGetTestSession(testName ?session sess)
      fprintf(out "TEST %s TRAN %L\nSIMULATOR %L\nENVIRONMENT %L\n" testName maeGetAnalysis(testName "tran" ?session sess) maeGetSimOption(testName ?session sess) maeGetEnvOption(testName ?session sess))
      fprintf(controls "// Native ADE format preview: %s\n" testName)
      errset(asiFormatAnalysis(asiGetAnalysis(th 'tran) controls) t)
    )
    foreach(testName list("active_noise_sb63" "passive_noise_sb63")
      th=maeGetTestSession(testName ?session sess)
      fprintf(out "TEST %s PSS %L\nPAC %L\nPNOISE %L\n" testName maeGetAnalysis(testName "pss" ?session sess) maeGetAnalysis(testName "pac" ?session sess) maeGetAnalysis(testName "pnoise" ?session sess))
      fprintf(controls "// Native ADE format preview: %s\n" testName)
      foreach(analysisName list('pss 'pac 'pnoise)
        errset(asiFormatAnalysis(asiGetAnalysis(th analysisName) controls) t)
      )
      foreach(fieldName list('outType 'inType 'sweeptype)
        fprintf(out "PNOISE_CHOICES %L %L\n" fieldName asiGetAnalysisFieldChoices(asiGetAnalysis(th 'pnoise) fieldName))
      )
    )
    close(controls)
    close(out)
    printf("HW09 existing session finalized. Only two baseline tests are enabled; start GUI Run All.\n")
    windowNumber=axlGetSessionWindowNumber(sess)
    printf("HW09 native ADE session %L GUI window number %L.\n" sess windowNumber)
    if(and(numberp(windowNumber) windowNumber>0) then
      hiRaiseWindow(windowNumber t)
    else
      ; The saved SKILL/batch handle does not own a graphical matrix.
      ; No simulations have been submitted; save and close only that handle.
      maeSaveSetup(?session sess)
      unless(maeCloseSession(?session sess ?forceClose nil)
        error("Could not close the saved batch handle before GUI opening.\n"))
      guiWindow=deOpenCellView("HW09_Mixers" "mixer_campaign" "maestro" "" nil "a")
      printf("HW09 maestro view opened through the native GUI dispatcher: %L.\n" guiWindow)
      when(guiWindow errset(hiRaiseWindow(guiWindow) t))
    )
    sess
  )
)
hw09ADEFinalize()
