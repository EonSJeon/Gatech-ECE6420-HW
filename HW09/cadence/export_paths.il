; Export actual point-1 directories from the completed native GUI history.
; This fixed campaign uses one constant-valued point per named test, no sweeps.
; The native top-level /psf/<test>/ paths are templates and are not exported.
procedure(hw09ExportCompletedGUIPaths()
  let((sess hid historyName saveRoot historyRoot pointRoot out psf netlist wn)
    foreach(existing maeGetSessions()
      when(and(equal(axlGetSessionLibName(existing) "HW09_Mixers")
               equal(axlGetSessionCellName(existing) "mixer_campaign")) sess=existing)
    )
    unless(sess error("Open the saved HW09 maestro GUI before exporting paths.\n"))
    hid=axlGetCurrentHistory(sess)
    unless(hid error("No native GUI history is selected.\n"))
    historyName=axlGetHistoryName(hid)
    saveRoot=envGetVal("adexl.results" "saveResDir")
    unless(and(stringp(saveRoot) stringp(historyName)) error("Missing native GUI result root or history name.\n"))
    historyRoot=strcat(saveRoot "/HW09_Mixers/mixer_campaign/maestro/results/maestro/" historyName)
    pointRoot=strcat(historyRoot "/1")
    unless(isDir(pointRoot) error("Actual native point-1 directory does not exist: %s\n" pointRoot))
    when(isDir(strcat(historyRoot "/2"))
      error("This exporter is for the fixed one-point-per-test campaign. Additional sweep points require RDB point enumeration.\n"))
    out=outfile("/nethome/sjeon84/Gatech-ECE6420/HW09/ade_native_paths.tsv")
    fprintf(out "history\tpoint_id\ttest_name\tpsf_directory\tnetlist_directory\n")
    foreach(testName maeGetSetup(?enabled t ?session sess)
      psf=strcat(pointRoot "/" testName "/psf")
      netlist=strcat(pointRoot "/" testName "/netlist")
      unless(and(isDir(psf) isFile(strcat(netlist "/input.scs")))
        close(out)
        error("Native completed point files are missing for %s. No template path will be substituted.\n" testName))
      fprintf(out "%L\t1\t%L\t%L\t%L\n" historyName testName psf netlist)
    )
    close(out)
    maeSaveSetup(?session sess)
    wn=axlGetSessionWindowNumber(sess)
    when(and(numberp(wn) wn>0) hiRaiseWindow(wn t))
    printf("Verified actual native point-1 paths exported. No simulator was invoked.\n")
  )
)
hw09ExportCompletedGUIPaths()
